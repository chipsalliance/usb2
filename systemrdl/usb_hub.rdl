// SPDX-License-Identifier: Apache-2.0
//
// Licensed under the Apache License, Version 2.0 (the "License");
// you may not use this file except in compliance with the License.
// you may obtain a copy of the License at
//
// http://www.apache.org/licenses/LICENSE-2.0
//
// Unless required by applicable law or agreed to in writing, software
// distributed under the License is distributed on an "AS IS" BASIS,
// WITHOUT WARRANTIES OR CONDITIONS OF ANY KIND, either express or implied.
// See the License for the specific language governing permissions and
// limitations under the License.
//

// Address documentation for the externally implemented usb_ep0_hub_descr block.
addrmap usb_hub #(
    longint unsigned FIFO_WORDS = 172
) {
    name = "USB HUB Descriptor Storage";
    desc = "Bus-visible HUB storage initialized from the built-in C_EP0_ROM image. Word 15 controls HUB operation; all other implemented words are software-readable and writable shadow storage. The current EP0 response path reads C_EP0_ROM directly, so shadow-memory writes do not alter USB descriptor responses. Addresses at or above FIFO_WORDS within the rounded bus aperture read zero and ignore writes. Once CONTROL.ENABLE and CONTROL.DCON are both set, software cannot unlock the storage; deasserting USB_EnableHub does not clear either bit.";

    external mem {
        desc = "Software-readable and writable shadow words 0 through 14. Reset restores the corresponding C_EP0_ROM words. Writes are ignored while CONTROL.ENABLE and CONTROL.DCON are both set, and do not alter the current EP0 descriptor-response source.";
        mementries = 15;
        memwidth = 32;
        sw = rw;
    } DESCRIPTOR_LOW @ 0x00;

    reg {
        desc = "Controls HUB operation and upstream connection. All HUB storage becomes permanently software-write-locked until reset once ENABLE and DCON are both set.";
        field {
            sw = rw;
            hw = rw;
            hwset = true;
            precedence = hw;
            desc = "Set to one to enable HUB operation. The USB_EnableHub hardware override can also set this field. Once ENABLE and DCON are both set, software writes to all HUB storage, including this field, are ignored until reset.";
        } ENABLE[0:0] = 0;
        field {
            sw = rw;
            hw = na;
            desc = "Stored and read back by the register interface but unused by HUB logic. Software should write zero.";
        } RESERVED_LOW[15:1] = 0;
        field {
            sw = rw;
            hw = rw;
            hwset = true;
            precedence = hw;
            desc = "Set to one to connect the HUB device to the upstream USB bus. The USB_EnableHub hardware override can also set this field. Once ENABLE and DCON are both set, software writes to all HUB storage, including this field, are ignored until reset.";
        } DCON[16:16] = 0;
        field {
            sw = rw;
            hw = na;
            desc = "Stored and read back by the register interface but unused by HUB logic. Software should write zero.";
        } RESERVED_HIGH[31:17] = 0;
    } CONTROL @ 0x3c;

    external mem {
        desc = "Software-readable and writable shadow words 16 through FIFO_WORDS minus one. Reset restores the corresponding C_EP0_ROM words. Writes are ignored while CONTROL.ENABLE and CONTROL.DCON are both set, and do not alter the current EP0 descriptor-response source.";
        mementries = FIFO_WORDS - 16;
        memwidth = 32;
        sw = rw;
    } DESCRIPTOR_HIGH @ 0x40;
};
