// SPDX-License-Identifier: Apache-2.0
//
// Licensed under the Apache License, Version 2.0 (the "License");
// you may not use this file except in compliance with the License.
// You may obtain a copy of the License at
//
// http://www.apache.org/licenses/LICENSE-2.0
//
// Unless required by applicable law or agreed to in writing, software
// distributed under the License is distributed on an "AS IS" BASIS,
// WITHOUT WARRANTIES OR CONDITIONS OF ANY KIND, either express or implied.
// See the License for the specific language governing permissions and
// limitations under the License.
//
// USB OCP Recovery v1.1 register map
//
// This file is the single source of truth for the USB transport view of the
// OCP Secure Firmware Recovery v1.1 command window.
// It is designed to provide firmware parity with existing implementations of
// OCP Recovery registers.

addrmap usb_ocp_recovery_reg {
    name = "USB OCP Recovery";
    desc = "USB transport OCP Secure Firmware Recovery v1.1 register aperture. OCP command fields follow OCP Recovery v1.1 Sec 9.2 command summaries, with USB-specific live-status behaviors aligned to usb_ocp_recovery_reg.sv and usb_ocp_recovery_cms_fifo.sv.";
    default regwidth = 32;
    default hw = na;
    signal {activelow; async;} rst_ni;
    default resetsignal = rst_ni;

    // PROT_CAP command (cmd 0x22, bytes 0-15).
    reg {
        name = "Recovery Protocol Capabilities 0";
        desc = "PROT_CAP bytes 0-3. OCP Recovery v1.1 Sec 9.2 PROT_CAP command.";
        field {
            name = "Recovery protocol magic string 0";
            desc = "ASCII bytes 0-3 of the OCP RECV magic string. OCP Recovery v1.1 Sec 9.2 PROT_CAP. Static read-only constant: the RDL reset is the single source of truth (no hw drive).";
            sw = r;
            hw = r;
            reset = 32'h2050434F;
        } REC_MAGIC_STRING_0[31:0];
    } PROT_CAP_0 @ 0x004;

    reg {
        name = "Recovery Protocol Capabilities 1";
        desc = "PROT_CAP bytes 4-7. OCP Recovery v1.1 Sec 9.2 PROT_CAP command.";
        field {
            name = "Recovery protocol magic string 1";
            desc = "ASCII bytes 4-7 of the OCP RECV magic string. OCP Recovery v1.1 Sec 9.2 PROT_CAP. Static read-only constant: the RDL reset is the single source of truth (no hw drive).";
            sw = r;
            hw = r;
            reset = 32'h56434552;
        } REC_MAGIC_STRING_1[31:0];
    } PROT_CAP_1;

    reg {
        name = "Recovery Protocol Capabilities 2";
        desc = "PROT_CAP bytes 8-11. OCP Recovery v1.1 Sec 9.2 PROT_CAP command.";
        field {
            name = "Recovery protocol version";
            desc = "Bytes 8-9 encode major=1 and minor=1 for OCP Recovery v1.1. OCP Recovery v1.1 Sec 9.2 PROT_CAP. Static read-only constant: the RDL reset is the single source of truth (no hw drive).";
            sw = r;
            hw = r;
            reset = 16'h0101;
        } REC_PROT_VERSION[15:0];
        // ----------------------------------------------------------------
        // AGENT_CAPS (PROT_CAP bytes 10-11) -- OCP Recovery v1.1 Sec 9.2
        // PROT_CAP "Recovery Protocol Capabilities" bitmap.
        // Bit names taken from the spec capability list.
        // FIFO-only agent; bit5 direct CMS-memory access cleared.
        // Reset defaults:
        //   bit0  IDENTIFICATION         0x0000 (fw enables after DEVICE_ID initialization)
        //   bit1  FORCED_RECOVERY        0x0002
        //   bit3  DEVICE_RESET           0x0008
        //   bit4  DEVICE_STATUS          0x0010
        //   bit7  PUSH_C_IMAGE           0x0080
        //   bit9  HARDWARE_STATUS        0x0200
        //   bit11 FLASHLESS_BOOT         0x0800
        //   bit12 FIFO_CMS_SUPPORT       0x1000
        //   ----------------------------- -------
        //   total                        0x1A9A
        // Each sub-field is firmware-configurable (sw=rw; hw=r) with the
        // above values as RESET defaults (OCP Recovery v1.1 Sec 9.2 PROT_CAP
        // is host-RO: the dedicated USB endpoint rejects a USB-host write and
        // raises PROTOCOL_ERROR. USB commands do not use the firmware CPUif.
        // ----------------------------------------------------------------
        field {
            name = "Identification";
            desc = "AGENT_CAPS bit 0: Identification (DEVICE_ID structure). OCP Recovery v1.1 Sec 9.2 PROT_CAP. Reset 0 so firmware can initialize DEVICE_ID before advertising it. Firmware-configurable (sw=rw); the USB host is RO because USB commands use the dedicated hardware endpoint, where a host write raises PROTOCOL_ERROR (Sec 9.1).";
            sw = rw;
            hw = r;
            reset = 1'b0;
        } AGENT_CAPS_IDENTIFICATION[16:16];
        field {
            name = "Forced Recovery";
            desc = "AGENT_CAPS bit 1: Forced Recovery (from RESET). OCP Recovery v1.1 Sec 9.2 PROT_CAP. Reset 1. Firmware-configurable (sw=rw); host writes raise PROTOCOL_ERROR.";
            sw = rw;
            hw = r;
            reset = 1'b1;
        } AGENT_CAPS_FORCED_RECOVERY[17:17];
        field {
            name = "Management Reset";
            desc = "AGENT_CAPS bit 2: Mgmt reset (from RESET). OCP Recovery v1.1 Sec 9.2 PROT_CAP. Not supported; reset 0. Firmware-configurable (sw=rw); host writes raise PROTOCOL_ERROR.";
            sw = rw;
            hw = r;
            reset = 1'b0;
        } AGENT_CAPS_MGMT_RESET[18:18];
        field {
            name = "Device Reset";
            desc = "AGENT_CAPS bit 3: Device Reset (from RESET). OCP Recovery v1.1 Sec 9.2 PROT_CAP. Reset 1. Firmware-configurable (sw=rw); host writes raise PROTOCOL_ERROR.";
            sw = rw;
            hw = r;
            reset = 1'b1;
        } AGENT_CAPS_DEVICE_RESET[19:19];
        field {
            name = "Device Status";
            desc = "AGENT_CAPS bit 4: Device status (DEVICE_STATUS). OCP Recovery v1.1 Sec 9.2 PROT_CAP. Reset 1. Firmware-configurable (sw=rw); host writes raise PROTOCOL_ERROR.";
            sw = rw;
            hw = r;
            reset = 1'b1;
        } AGENT_CAPS_DEVICE_STATUS[20:20];
        field {
            name = "Recovery Memory Access";
            desc = "AGENT_CAPS bit 5: Recovery memory access (direct CMS-memory window via INDIRECT_CTRL/STATUS/DATA, OCP commands 0x29/0x2A/0x2B). This agent is FIFO-only; the direct memory window is NOT implemented (the direct CMS-memory window register definitions were removed). Reset 0. OCP Recovery v1.1 Sec 9.2 PROT_CAP. Firmware-configurable (sw=rw); host writes raise PROTOCOL_ERROR.";
            sw = rw;
            hw = r;
            reset = 1'b0;
        } AGENT_CAPS_RECOVERY_MEM_ACCESS[21:21];
        field {
            name = "Local C-image Support";
            desc = "AGENT_CAPS bit 6: Local C-image support. OCP Recovery v1.1 Sec 9.2 PROT_CAP. Not supported; reset 0. Firmware-configurable (sw=rw); host writes raise PROTOCOL_ERROR.";
            sw = rw;
            hw = r;
            reset = 1'b0;
        } AGENT_CAPS_LOCAL_C_IMAGE[22:22];
        field {
            name = "Push C-image Support";
            desc = "AGENT_CAPS bit 7: Push C-image support (FIFO streaming boot). OCP Recovery v1.1 Sec 9.2 PROT_CAP. Reset 1. Firmware-configurable (sw=rw); host writes raise PROTOCOL_ERROR.";
            sw = rw;
            hw = r;
            reset = 1'b1;
        } AGENT_CAPS_PUSH_C_IMAGE[23:23];
        field {
            name = "Interface Isolation";
            desc = "AGENT_CAPS bit 8: Interface isolation. OCP Recovery v1.1 Sec 9.2 PROT_CAP. Not supported; reset 0. Firmware-configurable (sw=rw); host writes raise PROTOCOL_ERROR.";
            sw = rw;
            hw = r;
            reset = 1'b0;
        } AGENT_CAPS_INTERFACE_ISOLATION[24:24];
        field {
            name = "Hardware Status";
            desc = "AGENT_CAPS bit 9: Hardware status (HW_STATUS). OCP Recovery v1.1 Sec 9.2 PROT_CAP. Reset 1. Firmware-configurable (sw=rw); host writes raise PROTOCOL_ERROR.";
            sw = rw;
            hw = r;
            reset = 1'b1;
        } AGENT_CAPS_HARDWARE_STATUS[25:25];
        field {
            name = "Vendor Command";
            desc = "AGENT_CAPS bit 10: Vendor command (VENDOR). OCP Recovery v1.1 Sec 9.2 PROT_CAP. Reset 0. Firmware-configurable (sw=rw); host writes raise PROTOCOL_ERROR.";
            sw = rw;
            hw = r;
            reset = 1'b0;
        } AGENT_CAPS_VENDOR_COMMAND[26:26];
        field {
            name = "Flashless Boot";
            desc = "AGENT_CAPS bit 11: Flashless boot (from RESET). OCP Recovery v1.1 Sec 9.2 PROT_CAP. Advertised 1: this design supports flashless boot (host writes DEVICE_RESET.FORCED_RECOVERY=0xE to enter flashless boot on the next platform reset). Firmware-configurable (sw=rw), reset default 1; the USB host is RO -- a host write to PROT_CAP raises PROTOCOL_ERROR (Sec 9.1).";
            sw = rw;
            hw = r;
            reset = 1'b1;
        } AGENT_CAPS_FLASHLESS_BOOT[27:27];
        field {
            name = "FIFO CMS Support";
            desc = "AGENT_CAPS bit 12: FIFO CMS support (INDIRECT_FIFO_CTRL). OCP Recovery v1.1 Sec 9.2 PROT_CAP. Reset 1. Firmware-configurable (sw=rw); host writes raise PROTOCOL_ERROR.";
            sw = rw;
            hw = r;
            reset = 1'b1;
        } AGENT_CAPS_FIFO_CMS_SUPPORT[28:28];
        field {
            name = "Reserved";
            desc = "AGENT_CAPS bits 13-15: reserved. OCP Recovery v1.1 Sec 9.2 PROT_CAP. Reset 0.";
            sw = r;
            hw = r;
            reset = 3'b000;
        } AGENT_CAPS_RESERVED[31:29];
    } PROT_CAP_2;

    reg {
        name = "Recovery Protocol Capabilities 3";
        desc = "PROT_CAP bytes 12-15. OCP Recovery v1.1 Sec 9.2 PROT_CAP.";
        field {
            name = "Total number of CMS regions";
            desc = "Byte 12 reports the number of component memory spaces. Advertises one CMS region: after the direct CMS-memory window (INDIRECT_CTRL/STATUS/DATA) was removed, only the FIFO-backed CMS region remains (OCP Recovery v1.1 Sec 9.2 PROT_CAP; this count includes logging, code and vendor regions). Firmware-configurable (sw=rw), reset default 1; the USB host is RO -- a host write to PROT_CAP raises PROTOCOL_ERROR (Sec 9.1).";
            sw = rw;
            hw = r;
            reset = 8'h01;
        } NUM_OF_CMS_REGIONS[7:0];
        field {
            name = "Maximum response time";
            desc = "Byte 13 reports maximum response time in 2^x microseconds. OCP Recovery v1.1 Sec 9.2 PROT_CAP. Firmware-configurable (sw=rw); host writes raise PROTOCOL_ERROR.";
            sw = rw;
            hw = r;
            reset = 8'h00;
        } MAX_RESP_TIME[15:8];
        field {
            name = "Heartbeat period";
            desc = "Byte 14 reports heartbeat period in 2^x microseconds, with 0 meaning not supported. OCP Recovery v1.1 Sec 9.2 PROT_CAP. Firmware-configurable (sw=rw); host writes raise PROTOCOL_ERROR.";
            sw = rw;
            hw = r;
            reset = 8'h00;
        } HEARTBEAT_PERIOD[23:16];
        field {
            name = "Reserved";
            desc = "Byte 15 is reserved. OCP Recovery v1.1 Sec 9.2 PROT_CAP. Static read-only constant (sw=r; hw=na).";
            sw = r;
            hw = r;
            reset = 8'h00;
        } RESERVED_31_24[31:24];
    } PROT_CAP_3;

    // DEVICE_ID command (cmd 0x23, bytes 0-23).
    reg {
        name = "Device Identification 0";
        desc = "DEVICE_ID bytes 0-3. OCP Recovery v1.1 Sec 9.2 DEVICE_ID.";
        field {
            name = "Initial descriptor type";
            desc = "Byte 0 selects the DEVICE_ID encoding such as PCI, IANA, UUID, PnP, ACPI, or NVMe-MI. OCP Recovery v1.1 Sec 9.2 DEVICE_ID.";
            sw = rw;
            hw = r;
            reset = 8'h00;
        } DESC_TYPE[7:0];
        field {
            name = "Vendor specific string length";
            desc = "Byte 1 reports the optional vendor string length. OCP Recovery v1.1 Sec 9.2 DEVICE_ID.";
            sw = rw;
            hw = r;
            reset = 8'h00;
        } VENDOR_SPECIFIC_STR_LENGTH[15:8];
        field {
            name = "Descriptor payload bytes 2-3";
            desc = "Bytes 2-3 hold the first descriptor-specific payload bytes for the selected DEVICE_ID type. OCP Recovery v1.1 Sec 9.2 DEVICE_ID.";
            sw = rw;
            hw = r;
            reset = 16'h0000;
        } DATA_3_2[31:16];
    } DEVICE_ID_0 @ 0x014;

    reg {
        name = "Device Identification 1";
        desc = "DEVICE_ID bytes 4-7. OCP Recovery v1.1 Sec 9.2 DEVICE_ID.";
        field {
            name = "Device ID payload bytes 4-7";
            desc = "Bytes 4-7 carry descriptor-specific DEVICE_ID payload data for the selected descriptor type. OCP Recovery v1.1 Sec 9.2 DEVICE_ID.";
            sw = rw;
            hw = r;
            reset = 32'h00000000;
        } DATA_7_4[31:0];
    } DEVICE_ID_1;

    reg {
        name = "Device Identification 2";
        desc = "DEVICE_ID bytes 8-11. OCP Recovery v1.1 Sec 9.2 DEVICE_ID.";
        field {
            name = "Device ID payload bytes 8-11";
            desc = "Bytes 8-11 carry descriptor-specific DEVICE_ID payload data for the selected descriptor type. OCP Recovery v1.1 Sec 9.2 DEVICE_ID.";
            sw = rw;
            hw = r;
            reset = 32'h00000000;
        } DATA_11_8[31:0];
    } DEVICE_ID_2;

    reg {
        name = "Device Identification 3";
        desc = "DEVICE_ID bytes 12-15. OCP Recovery v1.1 Sec 9.2 DEVICE_ID.";
        field {
            name = "Device ID payload bytes 12-15";
            desc = "Bytes 12-15 carry descriptor-specific DEVICE_ID payload data for the selected descriptor type. OCP Recovery v1.1 Sec 9.2 DEVICE_ID.";
            sw = rw;
            hw = r;
            reset = 32'h00000000;
        } DATA_15_12[31:0];
    } DEVICE_ID_3;

    reg {
        name = "Device Identification 4";
        desc = "DEVICE_ID bytes 16-19. OCP Recovery v1.1 Sec 9.2 DEVICE_ID.";
        field {
            name = "Device ID payload bytes 16-19";
            desc = "Bytes 16-19 carry descriptor-specific DEVICE_ID payload data for the selected descriptor type. OCP Recovery v1.1 Sec 9.2 DEVICE_ID.";
            sw = rw;
            hw = r;
            reset = 32'h00000000;
        } DATA_19_16[31:0];
    } DEVICE_ID_4;

    reg {
        name = "Device Identification 5";
        desc = "DEVICE_ID bytes 20-23. OCP Recovery v1.1 Sec 9.2 DEVICE_ID.";
        field {
            name = "Device ID payload bytes 20-23";
            desc = "Bytes 20-23 carry descriptor-specific DEVICE_ID payload data for the selected descriptor type. OCP Recovery v1.1 Sec 9.2 DEVICE_ID.";
            sw = rw;
            hw = r;
            reset = 32'h00000000;
        } DATA_23_20[31:0];
    } DEVICE_ID_5;

    // DEVICE_STATUS command (cmd 0x24, bytes 0-63 in this USB implementation).
    reg {
        name = "Device Status 0";
        desc = "DEVICE_STATUS bytes 0-3. OCP Recovery v1.1 Sec 9.2 DEVICE_STATUS. The USB Recovery Agent read-clear action for PROTOCOL_ERROR is generated by the control-transfer decoder only after a completed USB read; internal firmware reads are non-destructive.";
        field {
            name = "Device status";
            desc = "Byte 0 reports device health and recovery state. Firmware owns the stored value through cpuif; the USB Recovery Agent reads the same value. OCP Recovery v1.1 Sec 9.2 DEVICE_STATUS.";
            sw = rw;
            hw = r;
            reset = 8'h01;
        } DEV_STATUS[7:0];
        field {
            name = "Protocol error";
            desc = "Byte 1 reports protocol error. OCP Recovery v1.1 Sec 9.2 defines clear-on-read for the Recovery Agent USB command; the control-transfer decoder performs that clear after a completed USB DEVICE_STATUS read. Internal firmware reads do not clear the field.";
            sw = r;
            hw = w;
            we = false;
            reset = 8'h00;
        } PROT_ERROR[15:8];
        field {
            name = "Recovery reason code";
            desc = "Bytes 2-3 report the 16-bit recovery reason code. Firmware owns the stored value through cpuif; the USB Recovery Agent reads the same value. OCP Recovery v1.1 Sec 9.2 DEVICE_STATUS and Table 3.";
            sw = rw;
            hw = r;
            reset = 16'h0000;
        } REC_REASON_CODE[31:16];
    } DEVICE_STATUS_0 @ 0x030;

    reg {
        name = "Device Status 1";
        desc = "DEVICE_STATUS bytes 4-7. OCP Recovery v1.1 Sec 9.2 DEVICE_STATUS.";
        field {
            name = "Heartbeat";
            desc = "Bytes 4-5 hold the heartbeat counter. OCP Recovery v1.1 Sec 9.2 DEVICE_STATUS.";
            sw = r;
            hw = w;
            we = false;
            reset = 16'h0000;
        } HEARTBEAT[15:0];
        field {
            name = "Vendor status length";
            desc = "Byte 6 reports the vendor status payload length. OCP Recovery v1.1 Sec 9.2 DEVICE_STATUS.";
            sw = r;
            hw = w;
            we = false;
            reset = 8'h00;
        } VENDOR_STATUS_LENGTH[23:16];
        field {
            name = "Vendor status byte 0";
            desc = "Byte 7 is the first byte of VENDOR_STATUS. OCP Recovery v1.1 Sec 9.2 DEVICE_STATUS.";
            sw = r;
            hw = w;
            we = false;
            reset = 8'h00;
        } VENDOR_STATUS_0[31:24];
    } DEVICE_STATUS_1;

    // DEVICE_RESET, RECOVERY_CTRL, RECOVERY_STATUS, and HW_STATUS commands.
    reg {
        name = "Reset control";
        desc = "DEVICE_RESET bytes 0-2 plus one pad byte. OCP Recovery v1.1 Sec 9.2 DEVICE_RESET. Firmware accesses the fields through cpuif; USB Recovery Agent writes use the hardware interface. Recovery FSM actions are qualified by the USB hardware write path, not by the firmware cpuif write.";
        field {
            name = "Device Reset Control";
            desc = "Byte 0 requests device reset or management reset. USB Recovery Agent writes use the hardware interface; firmware can read or clear the request through cpuif.";
            sw = rw;
            hw = rw;
            we = true;
            reset = 8'h00;
        } RESET_CTRL[7:0];
        field {
            name = "Forced Recovery";
            desc = "Byte 1 controls forced recovery or flashless boot on the next platform reset (0xE = enter flashless boot mode, 0xF = enter recovery mode). OCP Recovery v1.1 Sec 9.2 DEVICE_RESET.";
            sw = rw;
            hw = rw;
            we = true;
            reset = 8'h00;
        } FORCED_RECOVERY[15:8];
        field {
            name = "Interface Control";
            desc = "Byte 2 controls interface mastering enable. OCP Recovery v1.1 Sec 9.2 DEVICE_RESET.";
            sw = rw;
            hw = rw;
            we = true;
            reset = 8'h00;
        } IF_CTRL[23:16];
        field {
            name = "Reserved";
            desc = "Byte 3 is padding introduced by the DWORD-aligned RDL view and is not part of the OCP Recovery DEVICE_RESET command payload (OCP Recovery v1.1 Sec 9.2 DEVICE_RESET is 3 bytes). Matches the clean reserved byte-3 pattern of RECOVERY_CTRL.";
            sw = r;
            hw = na;
            reset = 8'h00;
        } RESERVED_31_24[31:24];
    } DEVICE_RESET @ 0x038;

    reg {
        name = "Recovery configuration/control";
        desc = "RECOVERY_CTRL bytes 0-2 plus one pad byte. OCP Recovery v1.1 Sec 9.2 RECOVERY_CTRL. Firmware accesses the fields through cpuif; USB Recovery Agent writes use the hardware interface. Recovery FSM actions are qualified by the USB hardware write path, not by the firmware cpuif write.";
        field {
            name = "Component Memory Space";
            desc = "Byte 0 selects the component memory space containing the recovery image. USB Recovery Agent writes use the hardware interface. OCP Recovery v1.1 Sec 9.2 RECOVERY_CTRL.";
            sw = rw;
            hw = rw;
            we = true;
            reset = 8'h00;
        } CMS[7:0];
        field {
            name = "Recovery Image Selection";
            desc = "Byte 1 selects memory-window or device-stored recovery image source. USB Recovery Agent writes use the hardware interface. OCP Recovery v1.1 Sec 9.2 RECOVERY_CTRL.";
            sw = rw;
            hw = rw;
            we = true;
            reset = 8'h00;
        } REC_IMG_SEL[15:8];
        field {
            name = "Activate Recovery Image";
            desc = "Byte 2 requests activation of the selected recovery image. The USB Recovery Agent writes 0x0F through the hardware interface; firmware can clear the stored request through cpuif after device handling. OCP Recovery v1.1 Sec 9.2 RECOVERY_CTRL.";
            sw = rw;
            hw = rw;
            we = true;
            swmod = true;
            reset = 8'h00;
        } ACTIVATE_REC_IMG[23:16];
        field {
            name = "Reserved";
            desc = "Byte 3 is padding introduced by the DWORD-aligned RDL view and is not part of the OCP command payload.";
            sw = r;
            hw = na;
            reset = 8'h00;
        } RESERVED_31_24[31:24];
    } RECOVERY_CTRL @ 0x03C;

    reg {
        name = "Recovery status";
        desc = "RECOVERY_STATUS bytes 0-1 plus pad bytes. OCP Recovery v1.1 Sec 9.2 RECOVERY_STATUS.";
        field {
            name = "Device recovery status";
            desc = "Byte 0 bits 3:0 report recovery status. Firmware owns the stored value through cpuif; the USB Recovery Agent reads the same value. OCP Recovery v1.1 Sec 9.2 RECOVERY_STATUS.";
            sw = rw;
            hw = r;
            reset = 4'h0;
        } DEV_REC_STATUS[3:0];
        field {
            name = "Recovery image index";
            desc = "Byte 0 bits 7:4 report the recovery image index. Firmware owns the stored value through cpuif; the USB Recovery Agent reads the same value. OCP Recovery v1.1 Sec 9.2 RECOVERY_STATUS.";
            sw = rw;
            hw = r;
            reset = 4'h0;
        } REC_IMG_INDEX[7:4];
        field {
            name = "Vendor specific status";
            desc = "Byte 1 reports vendor-specific recovery status. Firmware owns the stored value through cpuif; the USB Recovery Agent reads the same value. OCP Recovery v1.1 Sec 9.2 RECOVERY_STATUS.";
            sw = rw;
            hw = r;
            reset = 8'h00;
        } VENDOR_SPECIFIC_STATUS[15:8];
        field {
            name = "Reserved";
            desc = "Bytes 2-3 are padding introduced by the DWORD-aligned RDL view and are not part of the OCP command payload.";
            sw = r;
            hw = na;
            reset = 16'h0000;
        } RESERVED_31_16[31:16];
    } RECOVERY_STATUS @ 0x040;

    reg {
        name = "Hardware status";
        desc = "HW_STATUS bytes 0-3. OCP Recovery v1.1 Sec 9.2 HW_STATUS; byte layout follows the corrected usb_ocp_recovery_reg.sv implementation.";
        field {
            name = "Device temperature critical";
            desc = "Byte 0 bit 0 reports temperature-critical status. Firmware owns the stored byte through cpuif and the USB Recovery Agent reads the same storage. OCP Recovery v1.1 Sec 9.2 HW_STATUS.";
            sw = rw;
            hw = r;
            reset = 1'b0;
        } TEMP_CRITICAL[0:0];
        field {
            name = "Hardware soft error";
            desc = "Byte 0 bit 1 reports a hardware soft error. Firmware owns the stored byte through cpuif and the USB Recovery Agent reads the same storage. OCP Recovery v1.1 Sec 9.2 HW_STATUS.";
            sw = rw;
            hw = r;
            reset = 1'b0;
        } SOFT_ERR[1:1];
        field {
            name = "Hardware fatal error";
            desc = "Byte 0 bit 2 reports a hardware fatal error. Firmware owns the stored byte through cpuif and the USB Recovery Agent reads the same storage. OCP Recovery v1.1 Sec 9.2 HW_STATUS.";
            sw = rw;
            hw = r;
            reset = 1'b0;
        } FATAL_ERR[2:2];
        field {
            name = "Reserved";
            desc = "Byte 0 bits 7:3 are reserved. Firmware owns the stored byte through cpuif and the USB Recovery Agent reads the same storage. OCP Recovery v1.1 Sec 9.2 HW_STATUS.";
            sw = rw;
            hw = r;
            reset = 5'h00;
        } RESERVED_7_3[7:3];
        field {
            name = "Vendor HW status";
            desc = "Byte 1 holds the vendor HW status bitmap. Firmware owns the stored byte through cpuif and the USB Recovery Agent reads the same storage. This byte location matches the corrected usb_ocp_recovery_reg.sv layout and OCP Recovery v1.1 Sec 9.2 HW_STATUS.";
            sw = rw;
            hw = r;
            reset = 8'h00;
        } VENDOR_HW_STATUS[15:8];
        field {
            name = "Composite temperature";
            desc = "Byte 2 reports composite temperature. Firmware owns the stored byte through cpuif and the USB Recovery Agent reads the same storage. OCP Recovery v1.1 Sec 9.2 HW_STATUS.";
            sw = rw;
            hw = r;
            reset = 8'h00;
        } CTEMP[23:16];
        field {
            name = "Vendor HW status length";
            desc = "Byte 3 reports the vendor HW status payload length. Firmware owns the stored byte through cpuif and the USB Recovery Agent reads the same storage. This byte location matches the corrected usb_ocp_recovery_reg.sv layout and OCP Recovery v1.1 Sec 9.2 HW_STATUS.";
            sw = rw;
            hw = r;
            reset = 8'h00;
        } VENDOR_HW_STATUS_LEN[31:24];
    } HW_STATUS @ 0x044;

    // INDIRECT_FIFO_CTRL, INDIRECT_FIFO_STATUS, INDIRECT_FIFO_DATA, and VENDOR commands.
    reg {
        name = "Indirect FIFO Control 0";
        desc = "INDIRECT_FIFO_CTRL_0: CMS (byte 0), RESET (byte 1), reserved (bytes 2-3). The live owner of these fields is usb_ocp_recovery_cms_fifo.sv: it captures the host write on the FIFO command path and continuously drives this regblock copy (hw=w), so the regblock is the single read-back source (sw=r). This removes the prior duplication where the regblock held an independent sw=rw copy that the FIFO transport bypassed. OCP Recovery v1.1 Sec 9.2 INDIRECT_FIFO_CTRL command summary.";
        field {
            name = "Component Memory Space";
            desc = "Byte 0 selects the FIFO-backed component memory space. Firmware accesses route through cpuif, while usb_ocp_recovery_cms_fifo.sv remains the live owner and mirrors the committed state back through hw=w. OCP Recovery v1.1 Sec 9.2 INDIRECT_FIFO_CTRL command summary.";
            sw = rw;
            hw = w;
            we = false;
            swacc = true;
            reset = 8'h00;
        } CMS[7:0];
        field {
            name = "Reset";
            desc = "Byte 1 bit 0 requests FIFO reset and the device clears it after use. An accepted write of one produces a registered pulse; at its active edge FIFO storage, indices, progress, payload availability and status snapshot validity clear together. The same event clears BATCH_ABORTED and sets REGION_RESET, with priority over coincident abort and W1C respectively. Firmware accesses route through cpuif; usb_ocp_recovery_cms_fifo.sv owns the pulse and supplies readback through hw=w. OCP Recovery v1.1 Sec 9.2 INDIRECT_FIFO_CTRL command summary.";
            sw = rw;
            hw = w;
            we = false;
            reset = 8'h00;
        } RESET[15:8];
        field {
            name = "Reserved";
            desc = "Bytes 2-3 are reserved.";
            sw = r;
            hw = na;
            reset = 16'h0000;
        } RESERVED_31_16[31:16];
    } INDIRECT_FIFO_CTRL_0 @ 0x48;

    reg {
        name = "Indirect FIFO Control 1";
        desc = "INDIRECT_FIFO_CTRL_1: full 32-bit IMAGE_SIZE (image size to load, in 4-byte/DWORD units). The live owner is usb_ocp_recovery_cms_fifo.sv, which captures IMAGE_SIZE from the host FIFO command write and continuously drives this regblock copy (hw=w); the regblock is the single read-back source (sw=r). OCP Recovery v1.1 Sec 9.2 INDIRECT_FIFO_CTRL command summary.";
        field {
            name = "Image Size";
            desc = "Image size to load, in 4-byte (DWORD) units. Full 32-bit IMAGE_SIZE. Firmware accesses route through cpuif, while usb_ocp_recovery_cms_fifo.sv remains the live owner and mirrors the committed state back through hw=w.";
            sw = rw;
            hw = w;
            we = false;
            swacc = true;
            reset = 32'h00000000;
        } IMAGE_SIZE[31:0];
    } INDIRECT_FIFO_CTRL_1;

    reg {
        name = "Indirect FIFO Status 0";
        desc = "INDIRECT_FIFO_STATUS bytes 0-3: EMPTY, FULL, region type, and reserved bits. OCP Recovery v1.1 Sec 9.2 INDIRECT_FIFO_STATUS command summary.";
        field {
            name = "FIFO Empty";
            desc = "Byte 0 bit 0 indicates the FIFO is empty. OCP Recovery v1.1 Sec 9.2 INDIRECT_FIFO_STATUS command summary.";
            sw = r;
            hw = w;
            we = false;
            swacc = true;
            reset = 1'b1;
        } EMPTY[0:0];
        field {
            name = "FIFO Full";
            desc = "Byte 0 bit 1 indicates the FIFO is full. OCP Recovery v1.1 Sec 9.2 INDIRECT_FIFO_STATUS command summary.";
            sw = r;
            hw = w;
            we = false;
            reset = 1'b0;
        } FULL[1:1];
        field {
            name = "Reserved status bits";
            desc = "Byte 0 bits 7:2 are reserved in the OCP Recovery INDIRECT_FIFO_STATUS command (Sec 9.2 defines only bit 0 empty and bit 1 full). Caliptra-specific FIFO status (region reset / overflow / image done) lives in the CALIPTRA_STATUS register outside the OCP command aperture.";
            sw = r;
            hw = w;
            we = false;
            reset = 6'h0;
        } RESERVED_7_2[7:2];
        field {
            name = "Region type";
            desc = "Byte 1 reports the selected FIFO region type. The current USB implementation returns 0x00 for code space. OCP Recovery v1.1 Sec 9.2 INDIRECT_FIFO_STATUS command summary and usb_ocp_recovery_cms_fifo.sv.";
            sw = r;
            hw = w;
            we = false;
            reset = 8'h00;
        } REGION_TYPE[15:8];
        field {
            name = "Reserved";
            desc = "Bytes 2-3 are reserved. OCP Recovery v1.1 Sec 9.2 INDIRECT_FIFO_STATUS command summary.";
            sw = r;
            hw = w;
            we = false;
            reset = 16'h0000;
        } RESERVED_31_16[31:16];
    } INDIRECT_FIFO_STATUS_0 @ 0x50;

    reg {
        name = "Indirect FIFO Status 1";
        desc = "INDIRECT_FIFO_STATUS bytes 4-7. OCP Recovery v1.1 Sec 9.2 INDIRECT_FIFO_STATUS command summary.";
        field {
            name = "Write Index";
            desc = "Bytes 4-7 report WRITE_INDEX in 4-byte units. OCP Recovery v1.1 Sec 9.2 INDIRECT_FIFO_STATUS command summary.";
            sw = r;
            hw = w;
            we = false;
            swacc = true;
            reset = 32'h00000000;
        } WRITE_INDEX[31:0];
    } INDIRECT_FIFO_STATUS_1;

    reg {
        name = "Indirect FIFO Status 2";
        desc = "INDIRECT_FIFO_STATUS bytes 8-11. OCP Recovery v1.1 Sec 9.2 INDIRECT_FIFO_STATUS command summary.";
        field {
            name = "Read Index";
            desc = "Bytes 8-11 report READ_INDEX in 4-byte units. OCP Recovery v1.1 Sec 9.2 INDIRECT_FIFO_STATUS command summary.";
            sw = r;
            hw = w;
            we = false;
            swacc = true;
            reset = 32'h00000000;
        } READ_INDEX[31:0];
    } INDIRECT_FIFO_STATUS_2;

    reg {
        name = "Indirect FIFO Status 3";
        desc = "INDIRECT_FIFO_STATUS bytes 12-15. OCP Recovery v1.1 Sec 9.2 INDIRECT_FIFO_STATUS command summary.";
        field {
            name = "FIFO size";
            desc = "Bytes 12-15 report FIFO_SIZE in 4-byte units. OCP Recovery v1.1 Sec 9.2 INDIRECT_FIFO_STATUS command summary.";
            sw = r;
            hw = w;
            we = false;
            swacc = true;
            reset = 32'h00000000;
        } FIFO_SIZE[31:0];
    } INDIRECT_FIFO_STATUS_3;

    reg {
        name = "Indirect FIFO Status 4";
        desc = "INDIRECT_FIFO_STATUS bytes 16-19. OCP Recovery v1.1 Sec 9.2 INDIRECT_FIFO_STATUS command summary.";
        field {
            name = "Max transfer size";
            desc = "Bytes 16-19 report MAX_TRANSFER_SIZE in 4-byte units. OCP Recovery v1.1 Sec 9.2 INDIRECT_FIFO_STATUS command summary.";
            sw = r;
            hw = w;
            we = false;
            swacc = true;
            reset = 32'h00000000;
        } MAX_TRANSFER_SIZE[31:0];
    } INDIRECT_FIFO_STATUS_4;

    reg {
        name = "Indirect FIFO Data";
        desc = "INDIRECT_FIFO_DATA live FIFO head. OCP Recovery v1.1 Sec 9.2 INDIRECT_FIFO_DATA command summary. USB Recovery Agent writes bypass this CPU register endpoint and enter usb_ocp_recovery_cms_fifo directly. Firmware reads return the current FIFO head and pop exactly one valid entry.";
        field {
            name = "FIFO data";
            desc = "Live current FIFO-head DWORD. Software reads use hwif next directly with no generated payload storage. swacc is the accepted firmware read event used to pop one FIFO word. OCP Recovery v1.1 Sec 9.2 INDIRECT_FIFO_DATA command summary.";
            sw = r;
            hw = w;
            we = false;
            swacc = true;
            reset = 32'h00000000;
        } DATA[31:0];
    } INDIRECT_FIFO_DATA @ 0x68;

    reg {
        name = "Vendor command placeholder";
        desc = "One-byte VENDOR placeholder. OCP Recovery v1.1 Sec 9.2 VENDOR command summary. VENDOR aperture is a single byte placeholder pending future implementation.";
        field {
            name = "Vendor placeholder byte";
            desc = "Byte 0 placeholder for the vendor-defined command space. This project currently models only one byte, reset to 0. OCP Recovery v1.1 Sec 9.2 VENDOR command summary.";
            sw = rw;
            hw = rw;
            we = true;
            reset = 8'h00;
        } VENDOR_DATA[7:0];
        field {
            name = "Reserved";
            desc = "Bytes 1-3 are padding introduced by the DWORD-aligned RDL view and are not part of the current placeholder payload.";
            sw = r;
            hw = na;
            reset = 24'h000000;
        } RESERVED_31_8[31:8];
    } VENDOR @ 0x100;

    // Caliptra-specific registers, placed above the OCP Recovery command
    // aperture (the highest OCP command, VENDOR, ends at 0x1A7).  These are
    // NOT OCP Recovery commands: they carry no OCP wValue and are reached only
    // via the firmware/AXI (EXT) sub-decoder path, never the USB host command
    // decode, so they cannot perturb any spec-defined OCP command.
    reg {
        name = "Caliptra-specific control";
        desc = "Caliptra/vendor-specific control bits outside the OCP Recovery command set. Firmware (EXT/AXI) writable only.";
        field {
            name = "OCP Recovery Path Disable";
            desc = "Emergency-fallback control bit. When set, forces the VHDL post-synchronizer OCP recovery arbiter (usb_ocp_recovery_post_sync_arb.m.vhdl, ocp_path_disable_i port) to never claim an OCP-class SETUP, so every EP0 transfer falls through to the legacy SIE / MCU EPCS path bit-identically to the un-arbitered IP. Firmware/EXT writable only because CALIPTRA_CTRL is outside the USB command aperture. Reset default 0 (OCP recovery path active).";
            sw = rw;
            hw = r;
            reset = 1'b0;
        } OCP_PATH_DISABLE[0:0];
        field {
            name = "OCP Recovery Claim Abort";
            desc = "Firmware-only write-one request that atomically aborts an in-flight OCP recovery claim. Hardware consumes the request and clears the stored bit after one cycle. This is distinct from OCP_PATH_DISABLE, which persistently disables future OCP claims.";
            sw = rw;
            hw = rw;
            we = true;
            swmod = true;
            woset = true;
            reset = 1'b0;
        } OCP_CLAIM_ABORT[1:1];
        field {
            name = "OCP Protocol Error General";
            desc = "Firmware-only write-one request to report OCP_PROTOCOL_ERROR_GENERAL (0xFF) after an interrupted FIFO DATA batch. Hardware accepts the request only while CALIPTRA_STATUS.BATCH_ABORTED is asserted, enters persistent USB protocol STALL, and clears this stored request after one cycle.";
            sw = rw;
            hw = rw;
            we = true;
            swmod = true;
            woset = true;
            reset = 1'b0;
        } OCP_PROTOCOL_ERROR_GENERAL[2:2];
        field {
            name = "Reserved";
            desc = "Reserved for future Caliptra-specific control bits.";
            sw = r;
            hw = na;
            reset = 29'h0;
        } RESERVED_31_3[31:3];
    } CALIPTRA_CTRL @ 0x200;

    reg {
        name = "Caliptra-specific status";
        desc = "Caliptra/vendor-specific FIFO status and live registered post-sync arbiter state outside the OCP Recovery command set. Only REGION_RESET is stored here and firmware W1C; all other fields are live read-only hardware views. Reads are non-destructive.";
        field {
            name = "Region reset sticky status";
            desc = "Sticky explicit INDIRECT_FIFO_CTRL.RESET history stored in this generated field. The CMS explicit-reset pulse hardware-sets it at the actual FIFO flush. Firmware writes one with bit 0 enabled to clear only this flag; reads and zero writes have no effect. Hardware set wins simultaneous W1C. Core reset clears; bus/port reset and disconnect neither set nor clear this history. W1C does not flush payload or change other status.";
            sw = rw;
            onwrite = woclr;
            hw = r;
            hwset = true;
            precedence = hw;
            reset = 1'b0;
        } REGION_RESET[0:0];
        field {
            name = "Overflow sticky status";
            desc = "Sticky: set on a genuine FIFO-full overflow drop while the image is still incomplete. Driven by usb_ocp_recovery_cms_fifo.sv overflow_q.";
            sw = r;
            hw = w;
            we = false;
            reset = 1'b0;
        } OVERFLOW[1:1];
        field {
            name = "Image done sticky status";
            desc = "Sticky: set when the pushed DWORD count reaches the programmed image size. Driven by usb_ocp_recovery_cms_fifo.sv image_done_q.";
            sw = r;
            hw = w;
            we = false;
            reset = 1'b0;
        } IMAGE_DONE[2:2];
        field {
            name = "FIFO batch aborted sticky status";
            desc = "Sticky history of an aborted INDIRECT_FIFO_DATA request, including cancellation before any OUT DATA or a firmware-forced abort of a pending payload drain into FIFO. Complete accepted payloads and their drain are not aborted by replacement SETUP. Abort notification does not discard committed FIFO contents. Physical bus/port reset and disconnect clear payload but neither set nor clear this history. Explicit INDIRECT_FIFO_CTRL.RESET and core reset clear it, with explicit FIFO reset winning coincident abort. Firmware writes have no effect.";
            sw = r;
            hw = w;
            we = false;
            reset = 1'b0;
        } BATCH_ABORTED[3:3];
        field {
            name = "Live post-sync arbiter state";
            desc = "Diagnostic registered FSM state: 0 IDLE, 1 MIRROR, 2 META_WAIT, 3 DATA, 4 STATUS, 5 PROT_STALL; 6-7 reserved. Explicit encoding independent of synthesis state encoding. Not a readiness or firmware dispatch indication; not atomic with CALIPTRA_SETUP_DEBUG.";
            sw = r;
            hw = w;
            we = false;
            reset = 3'h0;
        } POST_SYNC_ARB_STATE[6:4];
        field {
            name = "Reserved";
            desc = "Reserved for future Caliptra-specific status bits.";
            sw = r;
            hw = w;
            we = false;
            reset = 25'h0;
        } RESERVED_31_7[31:7];
    } CALIPTRA_STATUS @ 0x204;

    reg {
        name = "Accepted Device0 EP0 SETUP debug";
        desc = "Last successfully accepted complete eight-byte Device0 EP0 SETUP. Generation and owner update atomically, independently of legacy SETUP notification forwarding. Debug only: neither a SRAM coherency/valid certificate nor a firmware dispatch indication. Reset on global reset, Device0 bus/port reset or disconnect; reset wins acceptance. Claim abort, protocol error, path disable and unrelated Hub/Device1 activity do not reset this word. Read-only and non-destructive.";
        field {
            name = "Accepted SETUP generation";
            desc = "Increments modulo 4096 once per accepted complete successful eight-byte Device0 EP0 SETUP, both owner classes, including accepted retries and commands that subsequently STALL. Bad-CRC, incomplete, wrong-length and non-SETUP traffic do not advance it. The debug update need not wait for the legacy SRAM mirror write drain.";
            sw = r;
            hw = w;
            we = false;
            reset = 12'h0;
        } GENERATION[11:0];
        field {
            name = "Accepted SETUP OCP ownership";
            desc = "1 for an accepted SETUP claimed by OCP Recovery, 0 for legacy. Describes the current accepted classification, not the previous retained EP0 owner. With OCP disabled the existing legacy fallback applies. Updates atomically with GENERATION.";
            sw = r;
            hw = w;
            we = false;
            reset = 1'b0;
        } OWNER_OCP[12:12];
        field {
            name = "Reserved";
            desc = "Read zero.";
            sw = r;
            hw = na;
            reset = 19'h0;
        } RESERVED_31_13[31:13];
    } CALIPTRA_SETUP_DEBUG @ 0x208;

    reg {
        name = "Window size pad";
        desc = "Padding register used only to force the elaborated usb_ocp_recovery addrmap size to a natural 2 KiB window ending at offset 0x7FC. The register block occupies the upper 2 KiB (offset 0x800-0xFFF) of the shared 4 KiB USB device subordinate window; usbhsd owns the lower 2 KiB (offset 0x000-0x7FF).";
        field {
            name = "Reserved pad";
            desc = "Not part of the OCP Recovery register set. This filler forces a 2 KiB elaborated addrmap for the SoC AHB sub-decoder window.";
            sw = r;
            hw = na;
            reset = 32'h00000000;
        } DATA[31:0];
    } WINDOW_PAD @ 0x7FC;

};
