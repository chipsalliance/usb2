// SPDX-License-Identifier: Apache-2.0
//
// Licensed under the Apache License, Version 2.0 (the "License");
// you may not use this file except in compliance with the License.
// You may obtain a copy of the License at
//
// http://www.apache.org/licenses/LICENSE-2.0
//
// Unless required by applicable law or agreed to in writing, software
// distributed under the License is distributed on an "AS IS" BASIS,
// WITHOUT WARRANTIES OR CONDITIONS OF ANY KIND, either express or implied.
// See the License for the specific language governing permissions and
// limitations under the License.
//
// USB OCP Recovery v1.1 register map
//
// This file is the single source of truth for the USB transport view of the
// OCP Secure Firmware Recovery v1.1 command window. It is modeled after the
// in-tree I3C reference RDL, but the top-level addrmap is flattened for direct
// placement at SOC_USB_OCP_RECOVERY_BASE_ADDR and the I3C-only EXTCAP_HEADER
// is intentionally omitted.

addrmap usb_ocp_recovery_reg {
    name = "USB OCP Recovery";
    desc = "USB transport OCP Secure Firmware Recovery v1.1 register aperture. OCP command fields follow OCP Recovery v1.1 Sec 9.2 command summaries, with USB-specific live-status behaviors aligned to usb_ocp_recovery_regs.sv and usb_ocp_recovery_cms_fifo.sv.";
    default regwidth = 32;
    default hw = na;

    // PROT_CAP command (cmd 0x22, bytes 0-15).
    reg {
        name = "Recovery Protocol Capabilities 0";
        desc = "PROT_CAP bytes 0-3. OCP Recovery v1.1 Sec 9.2 PROT_CAP command/Table 9-3.";
        field {
            name = "Recovery protocol magic string 0";
            desc = "ASCII bytes 0-3 of the OCP RECV magic string. OCP Recovery v1.1 Sec 9.2 PROT_CAP/Table 9-3.";
            sw = r;
            hw = w;
            we = false;
            reset = 32'h2050434F;
        } REC_MAGIC_STRING_0[31:0];
    } PROT_CAP_0 @ 0x000;

    reg {
        name = "Recovery Protocol Capabilities 1";
        desc = "PROT_CAP bytes 4-7. OCP Recovery v1.1 Sec 9.2 PROT_CAP command/Table 9-3.";
        field {
            name = "Recovery protocol magic string 1";
            desc = "ASCII bytes 4-7 of the OCP RECV magic string. OCP Recovery v1.1 Sec 9.2 PROT_CAP/Table 9-3.";
            sw = r;
            hw = w;
            we = false;
            reset = 32'h56434552;
        } REC_MAGIC_STRING_1[31:0];
    } PROT_CAP_1 @ 0x004;

    reg {
        name = "Recovery Protocol Capabilities 2";
        desc = "PROT_CAP bytes 8-11. OCP Recovery v1.1 Sec 9.2 PROT_CAP command/Table 9-3.";
        field {
            name = "Recovery protocol version";
            desc = "Bytes 8-9 encode major=1 and minor=1 for OCP Recovery v1.1. OCP Recovery v1.1 Sec 9.2 PROT_CAP/Table 9-3.";
            sw = r;
            hw = w;
            we = false;
            reset = 16'h0101;
        } REC_PROT_VERSION[15:0];
        field {
            name = "Recovery protocol capabilities";
            desc = "Bytes 10-11 advertise supported capabilities. This reset value matches the USB wrapper REC_PROT_CAP_DEFAULT bitmap in ip_xxx_3516_hs_mem_wrapper.sv and OCP Recovery v1.1 Sec 9.2 PROT_CAP/Table 9-3.";
            sw = r;
            hw = w;
            we = false;
            reset = 16'h16BB;
        } AGENT_CAPS[31:16];
    } PROT_CAP_2 @ 0x008;

    reg {
        name = "Recovery Protocol Capabilities 3";
        desc = "PROT_CAP bytes 12-15. OCP Recovery v1.1 Sec 9.2 PROT_CAP/Table 9-3.";
        field {
            name = "Total number of CMS regions";
            desc = "Byte 12 reports the number of component memory spaces. The USB wrapper currently advertises two CMS regions. OCP Recovery v1.1 Sec 9.2 PROT_CAP/Table 9-3.";
            sw = r;
            hw = w;
            we = false;
            reset = 8'h02;
        } NUM_OF_CMS_REGIONS[7:0];
        field {
            name = "Maximum response time";
            desc = "Byte 13 reports maximum response time in 2^x microseconds. OCP Recovery v1.1 Sec 9.2 PROT_CAP/Table 9-3.";
            sw = r;
            hw = w;
            we = false;
            reset = 8'h00;
        } MAX_RESP_TIME[15:8];
        field {
            name = "Heartbeat period";
            desc = "Byte 14 reports heartbeat period in 2^x microseconds, with 0 meaning not supported. OCP Recovery v1.1 Sec 9.2 PROT_CAP/Table 9-3.";
            sw = r;
            hw = w;
            we = false;
            reset = 8'h00;
        } HEARTBEAT_PERIOD[23:16];
        field {
            name = "Reserved";
            desc = "Byte 15 is reserved. OCP Recovery v1.1 Sec 9.2 PROT_CAP/Table 9-3.";
            sw = r;
            hw = w;
            we = false;
            reset = 8'h00;
        } RESERVED_31_24[31:24];
    } PROT_CAP_3 @ 0x00C;

    // DEVICE_ID command (cmd 0x23, bytes 0-23).
    reg {
        name = "Device Identification 0";
        desc = "DEVICE_ID bytes 0-3. OCP Recovery v1.1 Sec 9.2 DEVICE_ID/Table 9-4.";
        field {
            name = "Initial descriptor type";
            desc = "Byte 0 selects the DEVICE_ID encoding such as PCI, IANA, UUID, PnP, ACPI, or NVMe-MI. OCP Recovery v1.1 Sec 9.2 DEVICE_ID/Table 9-4.";
            sw = r;
            hw = w;
            we = false;
            reset = 8'h00;
        } DESC_TYPE[7:0];
        field {
            name = "Vendor specific string length";
            desc = "Byte 1 reports the optional vendor string length. OCP Recovery v1.1 Sec 9.2 DEVICE_ID/Table 9-4.";
            sw = r;
            hw = w;
            we = false;
            reset = 8'h00;
        } VENDOR_SPECIFIC_STR_LENGTH[15:8];
        field {
            name = "Descriptor payload bytes 2-3";
            desc = "Bytes 2-3 hold the first descriptor-specific payload bytes for the selected DEVICE_ID type. OCP Recovery v1.1 Sec 9.2 DEVICE_ID/Table 9-4.";
            sw = r;
            hw = w;
            we = false;
            reset = 16'h0000;
        } DATA_3_2[31:16];
    } DEVICE_ID_0 @ 0x010;

    reg {
        name = "Device Identification 1";
        desc = "DEVICE_ID bytes 4-7. OCP Recovery v1.1 Sec 9.2 DEVICE_ID/Table 9-4.";
        field {
            name = "Device ID payload bytes 4-7";
            desc = "Bytes 4-7 carry descriptor-specific DEVICE_ID payload data for the selected descriptor type. OCP Recovery v1.1 Sec 9.2 DEVICE_ID/Table 9-4.";
            sw = r;
            hw = w;
            we = false;
            reset = 32'h00000000;
        } DATA_7_4[31:0];
    } DEVICE_ID_1 @ 0x014;

    reg {
        name = "Device Identification 2";
        desc = "DEVICE_ID bytes 8-11. OCP Recovery v1.1 Sec 9.2 DEVICE_ID/Table 9-4.";
        field {
            name = "Device ID payload bytes 8-11";
            desc = "Bytes 8-11 carry descriptor-specific DEVICE_ID payload data for the selected descriptor type. OCP Recovery v1.1 Sec 9.2 DEVICE_ID/Table 9-4.";
            sw = r;
            hw = w;
            we = false;
            reset = 32'h00000000;
        } DATA_11_8[31:0];
    } DEVICE_ID_2 @ 0x018;

    reg {
        name = "Device Identification 3";
        desc = "DEVICE_ID bytes 12-15. OCP Recovery v1.1 Sec 9.2 DEVICE_ID/Table 9-4.";
        field {
            name = "Device ID payload bytes 12-15";
            desc = "Bytes 12-15 carry descriptor-specific DEVICE_ID payload data for the selected descriptor type. OCP Recovery v1.1 Sec 9.2 DEVICE_ID/Table 9-4.";
            sw = r;
            hw = w;
            we = false;
            reset = 32'h00000000;
        } DATA_15_12[31:0];
    } DEVICE_ID_3 @ 0x01C;

    reg {
        name = "Device Identification 4";
        desc = "DEVICE_ID bytes 16-19. OCP Recovery v1.1 Sec 9.2 DEVICE_ID/Table 9-4.";
        field {
            name = "Device ID payload bytes 16-19";
            desc = "Bytes 16-19 carry descriptor-specific DEVICE_ID payload data for the selected descriptor type. OCP Recovery v1.1 Sec 9.2 DEVICE_ID/Table 9-4.";
            sw = r;
            hw = w;
            we = false;
            reset = 32'h00000000;
        } DATA_19_16[31:0];
    } DEVICE_ID_4 @ 0x020;

    reg {
        name = "Device Identification 5";
        desc = "DEVICE_ID bytes 20-23. OCP Recovery v1.1 Sec 9.2 DEVICE_ID/Table 9-4.";
        field {
            name = "Device ID payload bytes 20-23";
            desc = "Bytes 20-23 carry descriptor-specific DEVICE_ID payload data for the selected descriptor type. OCP Recovery v1.1 Sec 9.2 DEVICE_ID/Table 9-4.";
            sw = r;
            hw = w;
            we = false;
            reset = 32'h00000000;
        } DATA_23_20[31:0];
    } DEVICE_ID_5 @ 0x024;

    // DEVICE_STATUS command (cmd 0x24, bytes 0-63 in this USB implementation).
    reg {
        name = "Device Status 0";
        desc = "DEVICE_STATUS bytes 0-3. OCP Recovery v1.1 Sec 9.2 DEVICE_STATUS/Table 9-5; PROTOCOL_ERROR clear-on-read behavior follows usb_ocp_recovery_regs.sv.";
        field {
            name = "Device status";
            desc = "Byte 0 reports device health and recovery state. OCP Recovery v1.1 Sec 9.2 DEVICE_STATUS/Table 9-5.";
            sw = r;
            hw = w;
            we = false;
            reset = 8'h00;
        } DEV_STATUS[7:0];
        field {
            name = "Protocol error";
            desc = "Byte 1 reports protocol error and clears on successful read, matching OCP Recovery v1.1 Sec 9.2 DEVICE_STATUS/Table 9-5 and usb_ocp_recovery_regs.sv proto_err_rd_pulse handling.";
            sw = r;
            hw = w;
            we = false;
            onread = rclr;
            reset = 8'h00;
        } PROT_ERROR[15:8];
        field {
            name = "Recovery reason code";
            desc = "Bytes 2-3 report the 16-bit recovery reason code. OCP Recovery v1.1 Sec 9.2 DEVICE_STATUS/Table 9-5 and Table 3.";
            sw = r;
            hw = w;
            we = false;
            reset = 16'h0000;
        } REC_REASON_CODE[31:16];
    } DEVICE_STATUS_0 @ 0x028;

    reg {
        name = "Device Status 1";
        desc = "DEVICE_STATUS bytes 4-7. OCP Recovery v1.1 Sec 9.2 DEVICE_STATUS/Table 9-5.";
        field {
            name = "Heartbeat";
            desc = "Bytes 4-5 hold the heartbeat counter. OCP Recovery v1.1 Sec 9.2 DEVICE_STATUS/Table 9-5.";
            sw = r;
            hw = w;
            we = false;
            reset = 16'h0000;
        } HEARTBEAT[15:0];
        field {
            name = "Vendor status length";
            desc = "Byte 6 reports the vendor status payload length. OCP Recovery v1.1 Sec 9.2 DEVICE_STATUS/Table 9-5.";
            sw = r;
            hw = w;
            we = false;
            reset = 8'h00;
        } VENDOR_STATUS_LENGTH[23:16];
        field {
            name = "Vendor status byte 0";
            desc = "Byte 7 is the first byte of VENDOR_STATUS. OCP Recovery v1.1 Sec 9.2 DEVICE_STATUS/Table 9-5.";
            sw = r;
            hw = w;
            we = false;
            reset = 8'h00;
        } VENDOR_STATUS_0[31:24];
    } DEVICE_STATUS_1 @ 0x02C;

    reg {
        name = "Device Status 2";
        desc = "DEVICE_STATUS bytes 8-11. OCP Recovery v1.1 Sec 9.2 DEVICE_STATUS/Table 9-5 vendor payload continuation.";
        field {
            name = "Vendor status bytes 1-4";
            desc = "Vendor status payload bytes 1-4, corresponding to overall DEVICE_STATUS bytes 8-11. OCP Recovery v1.1 Sec 9.2 DEVICE_STATUS/Table 9-5.";
            sw = r;
            hw = w;
            we = false;
            reset = 32'h00000000;
        } VENDOR_STATUS_4_1[31:0];
    } DEVICE_STATUS_2 @ 0x030;

    reg {
        name = "Device Status 3";
        desc = "DEVICE_STATUS bytes 12-15. OCP Recovery v1.1 Sec 9.2 DEVICE_STATUS/Table 9-5 vendor payload continuation.";
        field {
            name = "Vendor status bytes 5-8";
            desc = "Vendor status payload bytes 5-8, corresponding to overall DEVICE_STATUS bytes 12-15. OCP Recovery v1.1 Sec 9.2 DEVICE_STATUS/Table 9-5.";
            sw = r;
            hw = w;
            we = false;
            reset = 32'h00000000;
        } VENDOR_STATUS_8_5[31:0];
    } DEVICE_STATUS_3 @ 0x034;

    reg {
        name = "Device Status 4";
        desc = "DEVICE_STATUS bytes 16-19. OCP Recovery v1.1 Sec 9.2 DEVICE_STATUS/Table 9-5 vendor payload continuation.";
        field {
            name = "Vendor status bytes 9-12";
            desc = "Vendor status payload bytes 9-12, corresponding to overall DEVICE_STATUS bytes 16-19. OCP Recovery v1.1 Sec 9.2 DEVICE_STATUS/Table 9-5.";
            sw = r;
            hw = w;
            we = false;
            reset = 32'h00000000;
        } VENDOR_STATUS_12_9[31:0];
    } DEVICE_STATUS_4 @ 0x038;

    reg {
        name = "Device Status 5";
        desc = "DEVICE_STATUS bytes 20-23. OCP Recovery v1.1 Sec 9.2 DEVICE_STATUS/Table 9-5 vendor payload continuation.";
        field {
            name = "Vendor status bytes 13-16";
            desc = "Vendor status payload bytes 13-16, corresponding to overall DEVICE_STATUS bytes 20-23. OCP Recovery v1.1 Sec 9.2 DEVICE_STATUS/Table 9-5.";
            sw = r;
            hw = w;
            we = false;
            reset = 32'h00000000;
        } VENDOR_STATUS_16_13[31:0];
    } DEVICE_STATUS_5 @ 0x03C;

    reg {
        name = "Device Status 6";
        desc = "DEVICE_STATUS bytes 24-27. OCP Recovery v1.1 Sec 9.2 DEVICE_STATUS/Table 9-5 vendor payload continuation.";
        field {
            name = "Vendor status bytes 17-20";
            desc = "Vendor status payload bytes 17-20, corresponding to overall DEVICE_STATUS bytes 24-27. OCP Recovery v1.1 Sec 9.2 DEVICE_STATUS/Table 9-5.";
            sw = r;
            hw = w;
            we = false;
            reset = 32'h00000000;
        } VENDOR_STATUS_20_17[31:0];
    } DEVICE_STATUS_6 @ 0x040;

    reg {
        name = "Device Status 7";
        desc = "DEVICE_STATUS bytes 28-31. OCP Recovery v1.1 Sec 9.2 DEVICE_STATUS/Table 9-5 vendor payload continuation.";
        field {
            name = "Vendor status bytes 21-24";
            desc = "Vendor status payload bytes 21-24, corresponding to overall DEVICE_STATUS bytes 28-31. OCP Recovery v1.1 Sec 9.2 DEVICE_STATUS/Table 9-5.";
            sw = r;
            hw = w;
            we = false;
            reset = 32'h00000000;
        } VENDOR_STATUS_24_21[31:0];
    } DEVICE_STATUS_7 @ 0x044;

    reg {
        name = "Device Status 8";
        desc = "DEVICE_STATUS bytes 32-35. OCP Recovery v1.1 Sec 9.2 DEVICE_STATUS/Table 9-5 vendor payload continuation.";
        field {
            name = "Vendor status bytes 25-28";
            desc = "Vendor status payload bytes 25-28, corresponding to overall DEVICE_STATUS bytes 32-35. OCP Recovery v1.1 Sec 9.2 DEVICE_STATUS/Table 9-5.";
            sw = r;
            hw = w;
            we = false;
            reset = 32'h00000000;
        } VENDOR_STATUS_28_25[31:0];
    } DEVICE_STATUS_8 @ 0x048;

    reg {
        name = "Device Status 9";
        desc = "DEVICE_STATUS bytes 36-39. OCP Recovery v1.1 Sec 9.2 DEVICE_STATUS/Table 9-5 vendor payload continuation.";
        field {
            name = "Vendor status bytes 29-32";
            desc = "Vendor status payload bytes 29-32, corresponding to overall DEVICE_STATUS bytes 36-39. OCP Recovery v1.1 Sec 9.2 DEVICE_STATUS/Table 9-5.";
            sw = r;
            hw = w;
            we = false;
            reset = 32'h00000000;
        } VENDOR_STATUS_32_29[31:0];
    } DEVICE_STATUS_9 @ 0x04C;

    reg {
        name = "Device Status 10";
        desc = "DEVICE_STATUS bytes 40-43. OCP Recovery v1.1 Sec 9.2 DEVICE_STATUS/Table 9-5 vendor payload continuation.";
        field {
            name = "Vendor status bytes 33-36";
            desc = "Vendor status payload bytes 33-36, corresponding to overall DEVICE_STATUS bytes 40-43. OCP Recovery v1.1 Sec 9.2 DEVICE_STATUS/Table 9-5.";
            sw = r;
            hw = w;
            we = false;
            reset = 32'h00000000;
        } VENDOR_STATUS_36_33[31:0];
    } DEVICE_STATUS_10 @ 0x050;

    reg {
        name = "Device Status 11";
        desc = "DEVICE_STATUS bytes 44-47. OCP Recovery v1.1 Sec 9.2 DEVICE_STATUS/Table 9-5 vendor payload continuation.";
        field {
            name = "Vendor status bytes 37-40";
            desc = "Vendor status payload bytes 37-40, corresponding to overall DEVICE_STATUS bytes 44-47. OCP Recovery v1.1 Sec 9.2 DEVICE_STATUS/Table 9-5.";
            sw = r;
            hw = w;
            we = false;
            reset = 32'h00000000;
        } VENDOR_STATUS_40_37[31:0];
    } DEVICE_STATUS_11 @ 0x054;

    reg {
        name = "Device Status 12";
        desc = "DEVICE_STATUS bytes 48-51. OCP Recovery v1.1 Sec 9.2 DEVICE_STATUS/Table 9-5 vendor payload continuation.";
        field {
            name = "Vendor status bytes 41-44";
            desc = "Vendor status payload bytes 41-44, corresponding to overall DEVICE_STATUS bytes 48-51. OCP Recovery v1.1 Sec 9.2 DEVICE_STATUS/Table 9-5.";
            sw = r;
            hw = w;
            we = false;
            reset = 32'h00000000;
        } VENDOR_STATUS_44_41[31:0];
    } DEVICE_STATUS_12 @ 0x058;

    reg {
        name = "Device Status 13";
        desc = "DEVICE_STATUS bytes 52-55. OCP Recovery v1.1 Sec 9.2 DEVICE_STATUS/Table 9-5 vendor payload continuation.";
        field {
            name = "Vendor status bytes 45-48";
            desc = "Vendor status payload bytes 45-48, corresponding to overall DEVICE_STATUS bytes 52-55. OCP Recovery v1.1 Sec 9.2 DEVICE_STATUS/Table 9-5.";
            sw = r;
            hw = w;
            we = false;
            reset = 32'h00000000;
        } VENDOR_STATUS_48_45[31:0];
    } DEVICE_STATUS_13 @ 0x05C;

    reg {
        name = "Device Status 14";
        desc = "DEVICE_STATUS bytes 56-59. OCP Recovery v1.1 Sec 9.2 DEVICE_STATUS/Table 9-5 vendor payload continuation.";
        field {
            name = "Vendor status bytes 49-52";
            desc = "Vendor status payload bytes 49-52, corresponding to overall DEVICE_STATUS bytes 56-59. OCP Recovery v1.1 Sec 9.2 DEVICE_STATUS/Table 9-5.";
            sw = r;
            hw = w;
            we = false;
            reset = 32'h00000000;
        } VENDOR_STATUS_52_49[31:0];
    } DEVICE_STATUS_14 @ 0x060;

    reg {
        name = "Device Status 15";
        desc = "DEVICE_STATUS bytes 60-63. OCP Recovery v1.1 Sec 9.2 DEVICE_STATUS/Table 9-5 vendor payload continuation.";
        field {
            name = "Vendor status bytes 53-56";
            desc = "Vendor status payload bytes 53-56, corresponding to overall DEVICE_STATUS bytes 60-63. OCP Recovery v1.1 Sec 9.2 DEVICE_STATUS/Table 9-5.";
            sw = r;
            hw = w;
            we = false;
            reset = 32'h00000000;
        } VENDOR_STATUS_56_53[31:0];
    } DEVICE_STATUS_15 @ 0x064;

    // DEVICE_RESET, RECOVERY_CTRL, RECOVERY_STATUS, and HW_STATUS commands.
    reg {
        name = "Reset control";
        desc = "DEVICE_RESET bytes 0-2 plus one pad byte. OCP Recovery v1.1 Sec 9.2 DEVICE_RESET/Table 9-7. Each writable byte carries swmod so the SV recovery FSM sees a one-cycle write strobe directly from the CPUIF path.";
        field {
            name = "Device Reset Control";
            desc = "Byte 0 requests device reset or management reset. swmod gives the FSM a one-cycle write strobe, matching OCP Recovery v1.1 Sec 9.2 DEVICE_RESET/Table 9-7.";
            sw = w;
            hw = r;
            swmod = true;
            reset = 8'h00;
        } RESET_CTRL[7:0];
        field {
            name = "Forced Recovery";
            desc = "Byte 1 controls forced recovery or flashless boot on the next platform reset. OCP Recovery v1.1 Sec 9.2 DEVICE_RESET/Table 9-7.";
            sw = w;
            hw = r;
            swmod = true;
            reset = 8'h00;
        } FORCED_RECOVERY[15:8];
        field {
            name = "Interface Control";
            desc = "Byte 2 controls interface mastering enable. OCP Recovery v1.1 Sec 9.2 DEVICE_RESET/Table 9-7.";
            sw = w;
            hw = r;
            swmod = true;
            reset = 8'h00;
        } IF_CTRL[23:16];
        field {
            name = "Reserved";
            desc = "Byte 3 is padding introduced by the DWORD-aligned RDL view and is not part of the OCP command payload.";
            sw = r;
            hw = na;
            reset = 8'h00;
        } RESERVED_31_24[31:24];
    } DEVICE_RESET @ 0x068;

    reg {
        name = "Recovery configuration/control";
        desc = "RECOVERY_CTRL bytes 0-2 plus one pad byte. OCP Recovery v1.1 Sec 9.2 RECOVERY_CTRL/Table 9-9; CMS / REC_IMG_SEL carry swmod write strobes and ACTIVATE_REC_IMG is hardware-cleared by the recovery FSM consume pulse.";
        field {
            name = "Component Memory Space";
            desc = "Byte 0 selects the component memory space containing the recovery image. swmod gives the FSM a one-cycle write strobe. OCP Recovery v1.1 Sec 9.2 RECOVERY_CTRL/Table 9-9.";
            sw = rw;
            hw = r;
            swmod = true;
            reset = 8'h00;
        } CMS[7:0];
        field {
            name = "Recovery Image Selection";
            desc = "Byte 1 selects memory-window or device-stored recovery image source. swmod gives the FSM a one-cycle write strobe. OCP Recovery v1.1 Sec 9.2 RECOVERY_CTRL/Table 9-9.";
            sw = rw;
            hw = r;
            swmod = true;
            reset = 8'h00;
        } REC_IMG_SEL[15:8];
        field {
            name = "Activate Recovery Image";
            desc = "Byte 2 requests activation of the selected recovery image. The host writes 0x0F to request activation (OCP Recovery v1.1 Sec 9.2 RECOVERY_CTRL/Table 9-9); the recovery FSM consumes the request and hardware-clears the byte via hwclr. swmod gives the FSM a one-cycle write strobe.";
            sw = rw;
            hw = r;
            hwclr;
            swmod = true;
            reset = 8'h00;
        } ACTIVATE_REC_IMG[23:16];
        field {
            name = "Reserved";
            desc = "Byte 3 is padding introduced by the DWORD-aligned RDL view and is not part of the OCP command payload.";
            sw = r;
            hw = na;
            reset = 8'h00;
        } RESERVED_31_24[31:24];
    } RECOVERY_CTRL @ 0x06C;

    reg {
        name = "Recovery status";
        desc = "RECOVERY_STATUS bytes 0-1 plus pad bytes. OCP Recovery v1.1 Sec 9.2 RECOVERY_STATUS/Table 9-10.";
        field {
            name = "Device recovery status";
            desc = "Byte 0 bits 3:0 report recovery status. OCP Recovery v1.1 Sec 9.2 RECOVERY_STATUS/Table 9-10.";
            sw = r;
            hw = w;
            we = false;
            reset = 4'h0;
        } DEV_REC_STATUS[3:0];
        field {
            name = "Recovery image index";
            desc = "Byte 0 bits 7:4 report the recovery image index. OCP Recovery v1.1 Sec 9.2 RECOVERY_STATUS/Table 9-10.";
            sw = r;
            hw = w;
            we = false;
            reset = 4'h0;
        } REC_IMG_INDEX[7:4];
        field {
            name = "Vendor specific status";
            desc = "Byte 1 reports vendor-specific recovery status. OCP Recovery v1.1 Sec 9.2 RECOVERY_STATUS/Table 9-10.";
            sw = r;
            hw = w;
            we = false;
            reset = 8'h00;
        } VENDOR_SPECIFIC_STATUS[15:8];
        field {
            name = "Reserved";
            desc = "Bytes 2-3 are padding introduced by the DWORD-aligned RDL view and are not part of the OCP command payload.";
            sw = r;
            hw = na;
            reset = 16'h0000;
        } RESERVED_31_16[31:16];
    } RECOVERY_STATUS @ 0x070;

    reg {
        name = "Hardware status";
        desc = "HW_STATUS bytes 0-3. OCP Recovery v1.1 Sec 9.2 HW_STATUS/Table 9-11; byte layout follows the corrected usb_ocp_recovery_regs.sv implementation.";
        field {
            name = "Device temperature critical";
            desc = "Byte 0 bit 0 reports temperature-critical status. OCP Recovery v1.1 Sec 9.2 HW_STATUS/Table 9-11.";
            sw = r;
            hw = w;
            we = false;
            reset = 1'b0;
        } TEMP_CRITICAL[0:0];
        field {
            name = "Hardware soft error";
            desc = "Byte 0 bit 1 reports a hardware soft error. OCP Recovery v1.1 Sec 9.2 HW_STATUS/Table 9-11.";
            sw = r;
            hw = w;
            we = false;
            reset = 1'b0;
        } SOFT_ERR[1:1];
        field {
            name = "Hardware fatal error";
            desc = "Byte 0 bit 2 reports a hardware fatal error. OCP Recovery v1.1 Sec 9.2 HW_STATUS/Table 9-11.";
            sw = r;
            hw = w;
            we = false;
            reset = 1'b0;
        } FATAL_ERR[2:2];
        field {
            name = "Reserved";
            desc = "Byte 0 bits 7:3 are reserved. OCP Recovery v1.1 Sec 9.2 HW_STATUS/Table 9-11.";
            sw = r;
            hw = w;
            we = false;
            reset = 5'h00;
        } RESERVED_7_3[7:3];
        field {
            name = "Vendor HW status";
            desc = "Byte 1 holds the vendor HW status bitmap. This byte location matches the corrected usb_ocp_recovery_regs.sv layout and OCP Recovery v1.1 Sec 9.2 HW_STATUS/Table 9-11.";
            sw = r;
            hw = w;
            we = false;
            reset = 8'h00;
        } VENDOR_HW_STATUS[15:8];
        field {
            name = "Composite temperature";
            desc = "Byte 2 reports composite temperature. OCP Recovery v1.1 Sec 9.2 HW_STATUS/Table 9-11.";
            sw = r;
            hw = w;
            we = false;
            reset = 8'h00;
        } CTEMP[23:16];
        field {
            name = "Vendor HW status length";
            desc = "Byte 3 reports the vendor HW status payload length. This byte location matches the corrected usb_ocp_recovery_regs.sv layout and OCP Recovery v1.1 Sec 9.2 HW_STATUS/Table 9-11.";
            sw = r;
            hw = w;
            we = false;
            reset = 8'h00;
        } VENDOR_HW_STATUS_LEN[31:24];
    } HW_STATUS @ 0x074;

    // INDIRECT_CTRL, INDIRECT_STATUS, and INDIRECT_DATA commands.
    reg {
        name = "Indirect memory access control 0";
        desc = "INDIRECT_CTRL bytes 0-3. OCP Recovery v1.1 Sec 9.2 INDIRECT_CTRL/Table 9-12.";
        field {
            name = "Component Memory Space";
            desc = "Byte 0 selects the target component memory space. OCP Recovery v1.1 Sec 9.2 INDIRECT_CTRL/Table 9-12.";
            sw = rw;
            hw = r;
            reset = 8'h00;
        } CMS[7:0];
        field {
            name = "Reserved";
            desc = "Byte 1 is reserved but retained as a software-visible byte to preserve the OCP command layout. OCP Recovery v1.1 Sec 9.2 INDIRECT_CTRL/Table 9-12.";
            sw = rw;
            hw = r;
            reset = 8'h00;
        } RESERVED_15_8[15:8];
        field {
            name = "Indirect offset low";
            desc = "Bytes 2-3 hold the low 16 bits of the indirect memory offset in 4-byte units. OCP Recovery v1.1 Sec 9.2 INDIRECT_CTRL/Table 9-12.";
            sw = rw;
            hw = r;
            reset = 16'h0000;
        } INDIRECT_OFFSET_LOW[31:16];
    } INDIRECT_CTRL_0 @ 0x078;

    reg {
        name = "Indirect memory access control 1";
        desc = "INDIRECT_CTRL bytes 4-5 plus pad bytes. OCP Recovery v1.1 Sec 9.2 INDIRECT_CTRL/Table 9-12.";
        field {
            name = "Indirect offset high";
            desc = "Bytes 4-5 hold the high 16 bits of the indirect memory offset in 4-byte units. OCP Recovery v1.1 Sec 9.2 INDIRECT_CTRL/Table 9-12.";
            sw = rw;
            hw = r;
            reset = 16'h0000;
        } INDIRECT_OFFSET_HIGH[15:0];
        field {
            name = "Reserved";
            desc = "Bytes 6-7 are padding introduced by the DWORD-aligned RDL view and are not part of the OCP command payload.";
            sw = r;
            hw = na;
            reset = 16'h0000;
        } RESERVED_31_16[31:16];
    } INDIRECT_CTRL_1 @ 0x07C;

    reg {
        name = "Indirect memory access status 0";
        desc = "INDIRECT_STATUS bytes 0-3. OCP Recovery v1.1 Sec 9.2 INDIRECT_STATUS/Table 9-13, with live byte behavior matching usb_ocp_recovery_cms_fifo.sv.";
        field {
            name = "Empty";
            desc = "Byte 0 bit 0 reflects the USB cms_fifo direct-window empty state. This live status matches usb_ocp_recovery_cms_fifo.sv for the current USB transport implementation.";
            sw = r;
            hw = w;
            we = false;
            reset = 1'b1;
        } EMPTY[0:0];
        field {
            name = "Full";
            desc = "Byte 0 bit 1 reflects the USB cms_fifo direct-window full state. This live status matches usb_ocp_recovery_cms_fifo.sv for the current USB transport implementation.";
            sw = r;
            hw = w;
            we = false;
            reset = 1'b0;
        } FULL[1:1];
        field {
            name = "Reserved status bits";
            desc = "Byte 0 bits 7:2 are reserved in this USB transport view. The live cms_fifo currently drives only EMPTY and FULL in this byte.";
            sw = r;
            hw = w;
            we = false;
            reset = 6'h00;
        } RESERVED_7_2[7:2];
        field {
            name = "Region type";
            desc = "Byte 1 reports the selected region type. The current USB implementation returns 0x00 for code space. OCP Recovery v1.1 Sec 9.2 INDIRECT_STATUS/Table 9-13 and usb_ocp_recovery_cms_fifo.sv.";
            sw = r;
            hw = w;
            we = false;
            reset = 8'h00;
        } REGION_TYPE[15:8];
        field {
            name = "Region size low";
            desc = "Bytes 2-3 hold the low 16 bits of REGION_SIZE in 4-byte units. OCP Recovery v1.1 Sec 9.2 INDIRECT_STATUS/Table 9-13.";
            sw = r;
            hw = w;
            we = false;
            reset = 16'h0000;
        } REGION_SIZE_LOW[31:16];
    } INDIRECT_STATUS_0 @ 0x080;

    reg {
        name = "Indirect memory access status 1";
        desc = "INDIRECT_STATUS bytes 4-7. OCP Recovery v1.1 Sec 9.2 INDIRECT_STATUS/Table 9-13.";
        field {
            name = "Region size high";
            desc = "Bytes 4-7 hold the high 32 bits of REGION_SIZE in 4-byte units. OCP Recovery v1.1 Sec 9.2 INDIRECT_STATUS/Table 9-13.";
            sw = r;
            hw = w;
            we = false;
            reset = 32'h00000000;
        } REGION_SIZE_HIGH[31:0];
    } INDIRECT_STATUS_1 @ 0x084;

    reg {
        name = "Indirect memory data 0";
        desc = "INDIRECT_DATA bytes 0-3. OCP Recovery v1.1 Sec 9.2 INDIRECT_DATA/Table 9-14. Live data semantics are provided by usb_ocp_recovery_cms_fifo.sv through a future byte adapter.";
        field {
            name = "Indirect data bytes 0-3";
            desc = "Bytes 0-3 of the INDIRECT_DATA transfer window. OCP Recovery v1.1 Sec 9.2 INDIRECT_DATA/Table 9-14.";
            sw = rw;
            hw = rw;
            we = true;
            reset = 32'h00000000;
        } DATA_3_0[31:0];
    } INDIRECT_DATA_0 @ 0x088;

    reg {
        name = "Indirect memory data 1";
        desc = "INDIRECT_DATA bytes 4-7. OCP Recovery v1.1 Sec 9.2 INDIRECT_DATA/Table 9-14. Live data semantics are provided by usb_ocp_recovery_cms_fifo.sv through a future byte adapter.";
        field {
            name = "Indirect data bytes 4-7";
            desc = "Bytes 4-7 of the INDIRECT_DATA transfer window. OCP Recovery v1.1 Sec 9.2 INDIRECT_DATA/Table 9-14.";
            sw = rw;
            hw = rw;
            we = true;
            reset = 32'h00000000;
        } DATA_7_4[31:0];
    } INDIRECT_DATA_1 @ 0x08C;

    reg {
        name = "Indirect memory data 2";
        desc = "INDIRECT_DATA bytes 8-11. OCP Recovery v1.1 Sec 9.2 INDIRECT_DATA/Table 9-14. Live data semantics are provided by usb_ocp_recovery_cms_fifo.sv through a future byte adapter.";
        field {
            name = "Indirect data bytes 8-11";
            desc = "Bytes 8-11 of the INDIRECT_DATA transfer window. OCP Recovery v1.1 Sec 9.2 INDIRECT_DATA/Table 9-14.";
            sw = rw;
            hw = rw;
            we = true;
            reset = 32'h00000000;
        } DATA_11_8[31:0];
    } INDIRECT_DATA_2 @ 0x090;

    reg {
        name = "Indirect memory data 3";
        desc = "INDIRECT_DATA bytes 12-15. OCP Recovery v1.1 Sec 9.2 INDIRECT_DATA/Table 9-14. Live data semantics are provided by usb_ocp_recovery_cms_fifo.sv through a future byte adapter.";
        field {
            name = "Indirect data bytes 12-15";
            desc = "Bytes 12-15 of the INDIRECT_DATA transfer window. OCP Recovery v1.1 Sec 9.2 INDIRECT_DATA/Table 9-14.";
            sw = rw;
            hw = rw;
            we = true;
            reset = 32'h00000000;
        } DATA_15_12[31:0];
    } INDIRECT_DATA_3 @ 0x094;

    reg {
        name = "Indirect memory data 4";
        desc = "INDIRECT_DATA bytes 16-19. OCP Recovery v1.1 Sec 9.2 INDIRECT_DATA/Table 9-14. Live data semantics are provided by usb_ocp_recovery_cms_fifo.sv through a future byte adapter.";
        field {
            name = "Indirect data bytes 16-19";
            desc = "Bytes 16-19 of the INDIRECT_DATA transfer window. OCP Recovery v1.1 Sec 9.2 INDIRECT_DATA/Table 9-14.";
            sw = rw;
            hw = rw;
            we = true;
            reset = 32'h00000000;
        } DATA_19_16[31:0];
    } INDIRECT_DATA_4 @ 0x098;

    reg {
        name = "Indirect memory data 5";
        desc = "INDIRECT_DATA bytes 20-23. OCP Recovery v1.1 Sec 9.2 INDIRECT_DATA/Table 9-14. Live data semantics are provided by usb_ocp_recovery_cms_fifo.sv through a future byte adapter.";
        field {
            name = "Indirect data bytes 20-23";
            desc = "Bytes 20-23 of the INDIRECT_DATA transfer window. OCP Recovery v1.1 Sec 9.2 INDIRECT_DATA/Table 9-14.";
            sw = rw;
            hw = rw;
            we = true;
            reset = 32'h00000000;
        } DATA_23_20[31:0];
    } INDIRECT_DATA_5 @ 0x09C;

    reg {
        name = "Indirect memory data 6";
        desc = "INDIRECT_DATA bytes 24-27. OCP Recovery v1.1 Sec 9.2 INDIRECT_DATA/Table 9-14. Live data semantics are provided by usb_ocp_recovery_cms_fifo.sv through a future byte adapter.";
        field {
            name = "Indirect data bytes 24-27";
            desc = "Bytes 24-27 of the INDIRECT_DATA transfer window. OCP Recovery v1.1 Sec 9.2 INDIRECT_DATA/Table 9-14.";
            sw = rw;
            hw = rw;
            we = true;
            reset = 32'h00000000;
        } DATA_27_24[31:0];
    } INDIRECT_DATA_6 @ 0x0A0;

    reg {
        name = "Indirect memory data 7";
        desc = "INDIRECT_DATA bytes 28-31. OCP Recovery v1.1 Sec 9.2 INDIRECT_DATA/Table 9-14. Live data semantics are provided by usb_ocp_recovery_cms_fifo.sv through a future byte adapter.";
        field {
            name = "Indirect data bytes 28-31";
            desc = "Bytes 28-31 of the INDIRECT_DATA transfer window. OCP Recovery v1.1 Sec 9.2 INDIRECT_DATA/Table 9-14.";
            sw = rw;
            hw = rw;
            we = true;
            reset = 32'h00000000;
        } DATA_31_28[31:0];
    } INDIRECT_DATA_7 @ 0x0A4;

    reg {
        name = "Indirect memory data 8";
        desc = "INDIRECT_DATA bytes 32-35. OCP Recovery v1.1 Sec 9.2 INDIRECT_DATA/Table 9-14. Live data semantics are provided by usb_ocp_recovery_cms_fifo.sv through a future byte adapter.";
        field {
            name = "Indirect data bytes 32-35";
            desc = "Bytes 32-35 of the INDIRECT_DATA transfer window. OCP Recovery v1.1 Sec 9.2 INDIRECT_DATA/Table 9-14.";
            sw = rw;
            hw = rw;
            we = true;
            reset = 32'h00000000;
        } DATA_35_32[31:0];
    } INDIRECT_DATA_8 @ 0x0A8;

    reg {
        name = "Indirect memory data 9";
        desc = "INDIRECT_DATA bytes 36-39. OCP Recovery v1.1 Sec 9.2 INDIRECT_DATA/Table 9-14. Live data semantics are provided by usb_ocp_recovery_cms_fifo.sv through a future byte adapter.";
        field {
            name = "Indirect data bytes 36-39";
            desc = "Bytes 36-39 of the INDIRECT_DATA transfer window. OCP Recovery v1.1 Sec 9.2 INDIRECT_DATA/Table 9-14.";
            sw = rw;
            hw = rw;
            we = true;
            reset = 32'h00000000;
        } DATA_39_36[31:0];
    } INDIRECT_DATA_9 @ 0x0AC;

    reg {
        name = "Indirect memory data 10";
        desc = "INDIRECT_DATA bytes 40-43. OCP Recovery v1.1 Sec 9.2 INDIRECT_DATA/Table 9-14. Live data semantics are provided by usb_ocp_recovery_cms_fifo.sv through a future byte adapter.";
        field {
            name = "Indirect data bytes 40-43";
            desc = "Bytes 40-43 of the INDIRECT_DATA transfer window. OCP Recovery v1.1 Sec 9.2 INDIRECT_DATA/Table 9-14.";
            sw = rw;
            hw = rw;
            we = true;
            reset = 32'h00000000;
        } DATA_43_40[31:0];
    } INDIRECT_DATA_10 @ 0x0B0;

    reg {
        name = "Indirect memory data 11";
        desc = "INDIRECT_DATA bytes 44-47. OCP Recovery v1.1 Sec 9.2 INDIRECT_DATA/Table 9-14. Live data semantics are provided by usb_ocp_recovery_cms_fifo.sv through a future byte adapter.";
        field {
            name = "Indirect data bytes 44-47";
            desc = "Bytes 44-47 of the INDIRECT_DATA transfer window. OCP Recovery v1.1 Sec 9.2 INDIRECT_DATA/Table 9-14.";
            sw = rw;
            hw = rw;
            we = true;
            reset = 32'h00000000;
        } DATA_47_44[31:0];
    } INDIRECT_DATA_11 @ 0x0B4;

    reg {
        name = "Indirect memory data 12";
        desc = "INDIRECT_DATA bytes 48-51. OCP Recovery v1.1 Sec 9.2 INDIRECT_DATA/Table 9-14. Live data semantics are provided by usb_ocp_recovery_cms_fifo.sv through a future byte adapter.";
        field {
            name = "Indirect data bytes 48-51";
            desc = "Bytes 48-51 of the INDIRECT_DATA transfer window. OCP Recovery v1.1 Sec 9.2 INDIRECT_DATA/Table 9-14.";
            sw = rw;
            hw = rw;
            we = true;
            reset = 32'h00000000;
        } DATA_51_48[31:0];
    } INDIRECT_DATA_12 @ 0x0B8;

    reg {
        name = "Indirect memory data 13";
        desc = "INDIRECT_DATA bytes 52-55. OCP Recovery v1.1 Sec 9.2 INDIRECT_DATA/Table 9-14. Live data semantics are provided by usb_ocp_recovery_cms_fifo.sv through a future byte adapter.";
        field {
            name = "Indirect data bytes 52-55";
            desc = "Bytes 52-55 of the INDIRECT_DATA transfer window. OCP Recovery v1.1 Sec 9.2 INDIRECT_DATA/Table 9-14.";
            sw = rw;
            hw = rw;
            we = true;
            reset = 32'h00000000;
        } DATA_55_52[31:0];
    } INDIRECT_DATA_13 @ 0x0BC;

    reg {
        name = "Indirect memory data 14";
        desc = "INDIRECT_DATA bytes 56-59. OCP Recovery v1.1 Sec 9.2 INDIRECT_DATA/Table 9-14. Live data semantics are provided by usb_ocp_recovery_cms_fifo.sv through a future byte adapter.";
        field {
            name = "Indirect data bytes 56-59";
            desc = "Bytes 56-59 of the INDIRECT_DATA transfer window. OCP Recovery v1.1 Sec 9.2 INDIRECT_DATA/Table 9-14.";
            sw = rw;
            hw = rw;
            we = true;
            reset = 32'h00000000;
        } DATA_59_56[31:0];
    } INDIRECT_DATA_14 @ 0x0C0;

    reg {
        name = "Indirect memory data 15";
        desc = "INDIRECT_DATA bytes 60-63. OCP Recovery v1.1 Sec 9.2 INDIRECT_DATA/Table 9-14. Live data semantics are provided by usb_ocp_recovery_cms_fifo.sv through a future byte adapter.";
        field {
            name = "Indirect data bytes 60-63";
            desc = "Bytes 60-63 of the INDIRECT_DATA transfer window. OCP Recovery v1.1 Sec 9.2 INDIRECT_DATA/Table 9-14.";
            sw = rw;
            hw = rw;
            we = true;
            reset = 32'h00000000;
        } DATA_63_60[31:0];
    } INDIRECT_DATA_15 @ 0x0C4;

    reg {
        name = "Indirect memory data 16";
        desc = "INDIRECT_DATA bytes 64-67. OCP Recovery v1.1 Sec 9.2 INDIRECT_DATA/Table 9-14. Live data semantics are provided by usb_ocp_recovery_cms_fifo.sv through a future byte adapter.";
        field {
            name = "Indirect data bytes 64-67";
            desc = "Bytes 64-67 of the INDIRECT_DATA transfer window. OCP Recovery v1.1 Sec 9.2 INDIRECT_DATA/Table 9-14.";
            sw = rw;
            hw = rw;
            we = true;
            reset = 32'h00000000;
        } DATA_67_64[31:0];
    } INDIRECT_DATA_16 @ 0x0C8;

    reg {
        name = "Indirect memory data 17";
        desc = "INDIRECT_DATA bytes 68-71. OCP Recovery v1.1 Sec 9.2 INDIRECT_DATA/Table 9-14. Live data semantics are provided by usb_ocp_recovery_cms_fifo.sv through a future byte adapter.";
        field {
            name = "Indirect data bytes 68-71";
            desc = "Bytes 68-71 of the INDIRECT_DATA transfer window. OCP Recovery v1.1 Sec 9.2 INDIRECT_DATA/Table 9-14.";
            sw = rw;
            hw = rw;
            we = true;
            reset = 32'h00000000;
        } DATA_71_68[31:0];
    } INDIRECT_DATA_17 @ 0x0CC;

    reg {
        name = "Indirect memory data 18";
        desc = "INDIRECT_DATA bytes 72-75. OCP Recovery v1.1 Sec 9.2 INDIRECT_DATA/Table 9-14. Live data semantics are provided by usb_ocp_recovery_cms_fifo.sv through a future byte adapter.";
        field {
            name = "Indirect data bytes 72-75";
            desc = "Bytes 72-75 of the INDIRECT_DATA transfer window. OCP Recovery v1.1 Sec 9.2 INDIRECT_DATA/Table 9-14.";
            sw = rw;
            hw = rw;
            we = true;
            reset = 32'h00000000;
        } DATA_75_72[31:0];
    } INDIRECT_DATA_18 @ 0x0D0;

    reg {
        name = "Indirect memory data 19";
        desc = "INDIRECT_DATA bytes 76-79. OCP Recovery v1.1 Sec 9.2 INDIRECT_DATA/Table 9-14. Live data semantics are provided by usb_ocp_recovery_cms_fifo.sv through a future byte adapter.";
        field {
            name = "Indirect data bytes 76-79";
            desc = "Bytes 76-79 of the INDIRECT_DATA transfer window. OCP Recovery v1.1 Sec 9.2 INDIRECT_DATA/Table 9-14.";
            sw = rw;
            hw = rw;
            we = true;
            reset = 32'h00000000;
        } DATA_79_76[31:0];
    } INDIRECT_DATA_19 @ 0x0D4;

    reg {
        name = "Indirect memory data 20";
        desc = "INDIRECT_DATA bytes 80-83. OCP Recovery v1.1 Sec 9.2 INDIRECT_DATA/Table 9-14. Live data semantics are provided by usb_ocp_recovery_cms_fifo.sv through a future byte adapter.";
        field {
            name = "Indirect data bytes 80-83";
            desc = "Bytes 80-83 of the INDIRECT_DATA transfer window. OCP Recovery v1.1 Sec 9.2 INDIRECT_DATA/Table 9-14.";
            sw = rw;
            hw = rw;
            we = true;
            reset = 32'h00000000;
        } DATA_83_80[31:0];
    } INDIRECT_DATA_20 @ 0x0D8;

    reg {
        name = "Indirect memory data 21";
        desc = "INDIRECT_DATA bytes 84-87. OCP Recovery v1.1 Sec 9.2 INDIRECT_DATA/Table 9-14. Live data semantics are provided by usb_ocp_recovery_cms_fifo.sv through a future byte adapter.";
        field {
            name = "Indirect data bytes 84-87";
            desc = "Bytes 84-87 of the INDIRECT_DATA transfer window. OCP Recovery v1.1 Sec 9.2 INDIRECT_DATA/Table 9-14.";
            sw = rw;
            hw = rw;
            we = true;
            reset = 32'h00000000;
        } DATA_87_84[31:0];
    } INDIRECT_DATA_21 @ 0x0DC;

    reg {
        name = "Indirect memory data 22";
        desc = "INDIRECT_DATA bytes 88-91. OCP Recovery v1.1 Sec 9.2 INDIRECT_DATA/Table 9-14. Live data semantics are provided by usb_ocp_recovery_cms_fifo.sv through a future byte adapter.";
        field {
            name = "Indirect data bytes 88-91";
            desc = "Bytes 88-91 of the INDIRECT_DATA transfer window. OCP Recovery v1.1 Sec 9.2 INDIRECT_DATA/Table 9-14.";
            sw = rw;
            hw = rw;
            we = true;
            reset = 32'h00000000;
        } DATA_91_88[31:0];
    } INDIRECT_DATA_22 @ 0x0E0;

    reg {
        name = "Indirect memory data 23";
        desc = "INDIRECT_DATA bytes 92-95. OCP Recovery v1.1 Sec 9.2 INDIRECT_DATA/Table 9-14. Live data semantics are provided by usb_ocp_recovery_cms_fifo.sv through a future byte adapter.";
        field {
            name = "Indirect data bytes 92-95";
            desc = "Bytes 92-95 of the INDIRECT_DATA transfer window. OCP Recovery v1.1 Sec 9.2 INDIRECT_DATA/Table 9-14.";
            sw = rw;
            hw = rw;
            we = true;
            reset = 32'h00000000;
        } DATA_95_92[31:0];
    } INDIRECT_DATA_23 @ 0x0E4;

    reg {
        name = "Indirect memory data 24";
        desc = "INDIRECT_DATA bytes 96-99. OCP Recovery v1.1 Sec 9.2 INDIRECT_DATA/Table 9-14. Live data semantics are provided by usb_ocp_recovery_cms_fifo.sv through a future byte adapter.";
        field {
            name = "Indirect data bytes 96-99";
            desc = "Bytes 96-99 of the INDIRECT_DATA transfer window. OCP Recovery v1.1 Sec 9.2 INDIRECT_DATA/Table 9-14.";
            sw = rw;
            hw = rw;
            we = true;
            reset = 32'h00000000;
        } DATA_99_96[31:0];
    } INDIRECT_DATA_24 @ 0x0E8;

    reg {
        name = "Indirect memory data 25";
        desc = "INDIRECT_DATA bytes 100-103. OCP Recovery v1.1 Sec 9.2 INDIRECT_DATA/Table 9-14. Live data semantics are provided by usb_ocp_recovery_cms_fifo.sv through a future byte adapter.";
        field {
            name = "Indirect data bytes 100-103";
            desc = "Bytes 100-103 of the INDIRECT_DATA transfer window. OCP Recovery v1.1 Sec 9.2 INDIRECT_DATA/Table 9-14.";
            sw = rw;
            hw = rw;
            we = true;
            reset = 32'h00000000;
        } DATA_103_100[31:0];
    } INDIRECT_DATA_25 @ 0x0EC;

    reg {
        name = "Indirect memory data 26";
        desc = "INDIRECT_DATA bytes 104-107. OCP Recovery v1.1 Sec 9.2 INDIRECT_DATA/Table 9-14. Live data semantics are provided by usb_ocp_recovery_cms_fifo.sv through a future byte adapter.";
        field {
            name = "Indirect data bytes 104-107";
            desc = "Bytes 104-107 of the INDIRECT_DATA transfer window. OCP Recovery v1.1 Sec 9.2 INDIRECT_DATA/Table 9-14.";
            sw = rw;
            hw = rw;
            we = true;
            reset = 32'h00000000;
        } DATA_107_104[31:0];
    } INDIRECT_DATA_26 @ 0x0F0;

    reg {
        name = "Indirect memory data 27";
        desc = "INDIRECT_DATA bytes 108-111. OCP Recovery v1.1 Sec 9.2 INDIRECT_DATA/Table 9-14. Live data semantics are provided by usb_ocp_recovery_cms_fifo.sv through a future byte adapter.";
        field {
            name = "Indirect data bytes 108-111";
            desc = "Bytes 108-111 of the INDIRECT_DATA transfer window. OCP Recovery v1.1 Sec 9.2 INDIRECT_DATA/Table 9-14.";
            sw = rw;
            hw = rw;
            we = true;
            reset = 32'h00000000;
        } DATA_111_108[31:0];
    } INDIRECT_DATA_27 @ 0x0F4;

    reg {
        name = "Indirect memory data 28";
        desc = "INDIRECT_DATA bytes 112-115. OCP Recovery v1.1 Sec 9.2 INDIRECT_DATA/Table 9-14. Live data semantics are provided by usb_ocp_recovery_cms_fifo.sv through a future byte adapter.";
        field {
            name = "Indirect data bytes 112-115";
            desc = "Bytes 112-115 of the INDIRECT_DATA transfer window. OCP Recovery v1.1 Sec 9.2 INDIRECT_DATA/Table 9-14.";
            sw = rw;
            hw = rw;
            we = true;
            reset = 32'h00000000;
        } DATA_115_112[31:0];
    } INDIRECT_DATA_28 @ 0x0F8;

    reg {
        name = "Indirect memory data 29";
        desc = "INDIRECT_DATA bytes 116-119. OCP Recovery v1.1 Sec 9.2 INDIRECT_DATA/Table 9-14. Live data semantics are provided by usb_ocp_recovery_cms_fifo.sv through a future byte adapter.";
        field {
            name = "Indirect data bytes 116-119";
            desc = "Bytes 116-119 of the INDIRECT_DATA transfer window. OCP Recovery v1.1 Sec 9.2 INDIRECT_DATA/Table 9-14.";
            sw = rw;
            hw = rw;
            we = true;
            reset = 32'h00000000;
        } DATA_119_116[31:0];
    } INDIRECT_DATA_29 @ 0x0FC;

    reg {
        name = "Indirect memory data 30";
        desc = "INDIRECT_DATA bytes 120-123. OCP Recovery v1.1 Sec 9.2 INDIRECT_DATA/Table 9-14. Live data semantics are provided by usb_ocp_recovery_cms_fifo.sv through a future byte adapter.";
        field {
            name = "Indirect data bytes 120-123";
            desc = "Bytes 120-123 of the INDIRECT_DATA transfer window. OCP Recovery v1.1 Sec 9.2 INDIRECT_DATA/Table 9-14.";
            sw = rw;
            hw = rw;
            we = true;
            reset = 32'h00000000;
        } DATA_123_120[31:0];
    } INDIRECT_DATA_30 @ 0x100;

    reg {
        name = "Indirect memory data 31";
        desc = "INDIRECT_DATA bytes 124-127. OCP Recovery v1.1 Sec 9.2 INDIRECT_DATA/Table 9-14. Live data semantics are provided by usb_ocp_recovery_cms_fifo.sv through a future byte adapter.";
        field {
            name = "Indirect data bytes 124-127";
            desc = "Bytes 124-127 of the INDIRECT_DATA transfer window. OCP Recovery v1.1 Sec 9.2 INDIRECT_DATA/Table 9-14.";
            sw = rw;
            hw = rw;
            we = true;
            reset = 32'h00000000;
        } DATA_127_124[31:0];
    } INDIRECT_DATA_31 @ 0x104;

    reg {
        name = "Indirect memory data 32";
        desc = "INDIRECT_DATA bytes 128-131. OCP Recovery v1.1 Sec 9.2 INDIRECT_DATA/Table 9-14. Live data semantics are provided by usb_ocp_recovery_cms_fifo.sv through a future byte adapter.";
        field {
            name = "Indirect data bytes 128-131";
            desc = "Bytes 128-131 of the INDIRECT_DATA transfer window. OCP Recovery v1.1 Sec 9.2 INDIRECT_DATA/Table 9-14.";
            sw = rw;
            hw = rw;
            we = true;
            reset = 32'h00000000;
        } DATA_131_128[31:0];
    } INDIRECT_DATA_32 @ 0x108;

    reg {
        name = "Indirect memory data 33";
        desc = "INDIRECT_DATA bytes 132-135. OCP Recovery v1.1 Sec 9.2 INDIRECT_DATA/Table 9-14. Live data semantics are provided by usb_ocp_recovery_cms_fifo.sv through a future byte adapter.";
        field {
            name = "Indirect data bytes 132-135";
            desc = "Bytes 132-135 of the INDIRECT_DATA transfer window. OCP Recovery v1.1 Sec 9.2 INDIRECT_DATA/Table 9-14.";
            sw = rw;
            hw = rw;
            we = true;
            reset = 32'h00000000;
        } DATA_135_132[31:0];
    } INDIRECT_DATA_33 @ 0x10C;

    reg {
        name = "Indirect memory data 34";
        desc = "INDIRECT_DATA bytes 136-139. OCP Recovery v1.1 Sec 9.2 INDIRECT_DATA/Table 9-14. Live data semantics are provided by usb_ocp_recovery_cms_fifo.sv through a future byte adapter.";
        field {
            name = "Indirect data bytes 136-139";
            desc = "Bytes 136-139 of the INDIRECT_DATA transfer window. OCP Recovery v1.1 Sec 9.2 INDIRECT_DATA/Table 9-14.";
            sw = rw;
            hw = rw;
            we = true;
            reset = 32'h00000000;
        } DATA_139_136[31:0];
    } INDIRECT_DATA_34 @ 0x110;

    reg {
        name = "Indirect memory data 35";
        desc = "INDIRECT_DATA bytes 140-143. OCP Recovery v1.1 Sec 9.2 INDIRECT_DATA/Table 9-14. Live data semantics are provided by usb_ocp_recovery_cms_fifo.sv through a future byte adapter.";
        field {
            name = "Indirect data bytes 140-143";
            desc = "Bytes 140-143 of the INDIRECT_DATA transfer window. OCP Recovery v1.1 Sec 9.2 INDIRECT_DATA/Table 9-14.";
            sw = rw;
            hw = rw;
            we = true;
            reset = 32'h00000000;
        } DATA_143_140[31:0];
    } INDIRECT_DATA_35 @ 0x114;

    reg {
        name = "Indirect memory data 36";
        desc = "INDIRECT_DATA bytes 144-147. OCP Recovery v1.1 Sec 9.2 INDIRECT_DATA/Table 9-14. Live data semantics are provided by usb_ocp_recovery_cms_fifo.sv through a future byte adapter.";
        field {
            name = "Indirect data bytes 144-147";
            desc = "Bytes 144-147 of the INDIRECT_DATA transfer window. OCP Recovery v1.1 Sec 9.2 INDIRECT_DATA/Table 9-14.";
            sw = rw;
            hw = rw;
            we = true;
            reset = 32'h00000000;
        } DATA_147_144[31:0];
    } INDIRECT_DATA_36 @ 0x118;

    reg {
        name = "Indirect memory data 37";
        desc = "INDIRECT_DATA bytes 148-151. OCP Recovery v1.1 Sec 9.2 INDIRECT_DATA/Table 9-14. Live data semantics are provided by usb_ocp_recovery_cms_fifo.sv through a future byte adapter.";
        field {
            name = "Indirect data bytes 148-151";
            desc = "Bytes 148-151 of the INDIRECT_DATA transfer window. OCP Recovery v1.1 Sec 9.2 INDIRECT_DATA/Table 9-14.";
            sw = rw;
            hw = rw;
            we = true;
            reset = 32'h00000000;
        } DATA_151_148[31:0];
    } INDIRECT_DATA_37 @ 0x11C;

    reg {
        name = "Indirect memory data 38";
        desc = "INDIRECT_DATA bytes 152-155. OCP Recovery v1.1 Sec 9.2 INDIRECT_DATA/Table 9-14. Live data semantics are provided by usb_ocp_recovery_cms_fifo.sv through a future byte adapter.";
        field {
            name = "Indirect data bytes 152-155";
            desc = "Bytes 152-155 of the INDIRECT_DATA transfer window. OCP Recovery v1.1 Sec 9.2 INDIRECT_DATA/Table 9-14.";
            sw = rw;
            hw = rw;
            we = true;
            reset = 32'h00000000;
        } DATA_155_152[31:0];
    } INDIRECT_DATA_38 @ 0x120;

    reg {
        name = "Indirect memory data 39";
        desc = "INDIRECT_DATA bytes 156-159. OCP Recovery v1.1 Sec 9.2 INDIRECT_DATA/Table 9-14. Live data semantics are provided by usb_ocp_recovery_cms_fifo.sv through a future byte adapter.";
        field {
            name = "Indirect data bytes 156-159";
            desc = "Bytes 156-159 of the INDIRECT_DATA transfer window. OCP Recovery v1.1 Sec 9.2 INDIRECT_DATA/Table 9-14.";
            sw = rw;
            hw = rw;
            we = true;
            reset = 32'h00000000;
        } DATA_159_156[31:0];
    } INDIRECT_DATA_39 @ 0x124;

    reg {
        name = "Indirect memory data 40";
        desc = "INDIRECT_DATA bytes 160-163. OCP Recovery v1.1 Sec 9.2 INDIRECT_DATA/Table 9-14. Live data semantics are provided by usb_ocp_recovery_cms_fifo.sv through a future byte adapter.";
        field {
            name = "Indirect data bytes 160-163";
            desc = "Bytes 160-163 of the INDIRECT_DATA transfer window. OCP Recovery v1.1 Sec 9.2 INDIRECT_DATA/Table 9-14.";
            sw = rw;
            hw = rw;
            we = true;
            reset = 32'h00000000;
        } DATA_163_160[31:0];
    } INDIRECT_DATA_40 @ 0x128;

    reg {
        name = "Indirect memory data 41";
        desc = "INDIRECT_DATA bytes 164-167. OCP Recovery v1.1 Sec 9.2 INDIRECT_DATA/Table 9-14. Live data semantics are provided by usb_ocp_recovery_cms_fifo.sv through a future byte adapter.";
        field {
            name = "Indirect data bytes 164-167";
            desc = "Bytes 164-167 of the INDIRECT_DATA transfer window. OCP Recovery v1.1 Sec 9.2 INDIRECT_DATA/Table 9-14.";
            sw = rw;
            hw = rw;
            we = true;
            reset = 32'h00000000;
        } DATA_167_164[31:0];
    } INDIRECT_DATA_41 @ 0x12C;

    reg {
        name = "Indirect memory data 42";
        desc = "INDIRECT_DATA bytes 168-171. OCP Recovery v1.1 Sec 9.2 INDIRECT_DATA/Table 9-14. Live data semantics are provided by usb_ocp_recovery_cms_fifo.sv through a future byte adapter.";
        field {
            name = "Indirect data bytes 168-171";
            desc = "Bytes 168-171 of the INDIRECT_DATA transfer window. OCP Recovery v1.1 Sec 9.2 INDIRECT_DATA/Table 9-14.";
            sw = rw;
            hw = rw;
            we = true;
            reset = 32'h00000000;
        } DATA_171_168[31:0];
    } INDIRECT_DATA_42 @ 0x130;

    reg {
        name = "Indirect memory data 43";
        desc = "INDIRECT_DATA bytes 172-175. OCP Recovery v1.1 Sec 9.2 INDIRECT_DATA/Table 9-14. Live data semantics are provided by usb_ocp_recovery_cms_fifo.sv through a future byte adapter.";
        field {
            name = "Indirect data bytes 172-175";
            desc = "Bytes 172-175 of the INDIRECT_DATA transfer window. OCP Recovery v1.1 Sec 9.2 INDIRECT_DATA/Table 9-14.";
            sw = rw;
            hw = rw;
            we = true;
            reset = 32'h00000000;
        } DATA_175_172[31:0];
    } INDIRECT_DATA_43 @ 0x134;

    reg {
        name = "Indirect memory data 44";
        desc = "INDIRECT_DATA bytes 176-179. OCP Recovery v1.1 Sec 9.2 INDIRECT_DATA/Table 9-14. Live data semantics are provided by usb_ocp_recovery_cms_fifo.sv through a future byte adapter.";
        field {
            name = "Indirect data bytes 176-179";
            desc = "Bytes 176-179 of the INDIRECT_DATA transfer window. OCP Recovery v1.1 Sec 9.2 INDIRECT_DATA/Table 9-14.";
            sw = rw;
            hw = rw;
            we = true;
            reset = 32'h00000000;
        } DATA_179_176[31:0];
    } INDIRECT_DATA_44 @ 0x138;

    reg {
        name = "Indirect memory data 45";
        desc = "INDIRECT_DATA bytes 180-183. OCP Recovery v1.1 Sec 9.2 INDIRECT_DATA/Table 9-14. Live data semantics are provided by usb_ocp_recovery_cms_fifo.sv through a future byte adapter.";
        field {
            name = "Indirect data bytes 180-183";
            desc = "Bytes 180-183 of the INDIRECT_DATA transfer window. OCP Recovery v1.1 Sec 9.2 INDIRECT_DATA/Table 9-14.";
            sw = rw;
            hw = rw;
            we = true;
            reset = 32'h00000000;
        } DATA_183_180[31:0];
    } INDIRECT_DATA_45 @ 0x13C;

    reg {
        name = "Indirect memory data 46";
        desc = "INDIRECT_DATA bytes 184-187. OCP Recovery v1.1 Sec 9.2 INDIRECT_DATA/Table 9-14. Live data semantics are provided by usb_ocp_recovery_cms_fifo.sv through a future byte adapter.";
        field {
            name = "Indirect data bytes 184-187";
            desc = "Bytes 184-187 of the INDIRECT_DATA transfer window. OCP Recovery v1.1 Sec 9.2 INDIRECT_DATA/Table 9-14.";
            sw = rw;
            hw = rw;
            we = true;
            reset = 32'h00000000;
        } DATA_187_184[31:0];
    } INDIRECT_DATA_46 @ 0x140;

    reg {
        name = "Indirect memory data 47";
        desc = "INDIRECT_DATA bytes 188-191. OCP Recovery v1.1 Sec 9.2 INDIRECT_DATA/Table 9-14. Live data semantics are provided by usb_ocp_recovery_cms_fifo.sv through a future byte adapter.";
        field {
            name = "Indirect data bytes 188-191";
            desc = "Bytes 188-191 of the INDIRECT_DATA transfer window. OCP Recovery v1.1 Sec 9.2 INDIRECT_DATA/Table 9-14.";
            sw = rw;
            hw = rw;
            we = true;
            reset = 32'h00000000;
        } DATA_191_188[31:0];
    } INDIRECT_DATA_47 @ 0x144;

    reg {
        name = "Indirect memory data 48";
        desc = "INDIRECT_DATA bytes 192-195. OCP Recovery v1.1 Sec 9.2 INDIRECT_DATA/Table 9-14. Live data semantics are provided by usb_ocp_recovery_cms_fifo.sv through a future byte adapter.";
        field {
            name = "Indirect data bytes 192-195";
            desc = "Bytes 192-195 of the INDIRECT_DATA transfer window. OCP Recovery v1.1 Sec 9.2 INDIRECT_DATA/Table 9-14.";
            sw = rw;
            hw = rw;
            we = true;
            reset = 32'h00000000;
        } DATA_195_192[31:0];
    } INDIRECT_DATA_48 @ 0x148;

    reg {
        name = "Indirect memory data 49";
        desc = "INDIRECT_DATA bytes 196-199. OCP Recovery v1.1 Sec 9.2 INDIRECT_DATA/Table 9-14. Live data semantics are provided by usb_ocp_recovery_cms_fifo.sv through a future byte adapter.";
        field {
            name = "Indirect data bytes 196-199";
            desc = "Bytes 196-199 of the INDIRECT_DATA transfer window. OCP Recovery v1.1 Sec 9.2 INDIRECT_DATA/Table 9-14.";
            sw = rw;
            hw = rw;
            we = true;
            reset = 32'h00000000;
        } DATA_199_196[31:0];
    } INDIRECT_DATA_49 @ 0x14C;

    reg {
        name = "Indirect memory data 50";
        desc = "INDIRECT_DATA bytes 200-203. OCP Recovery v1.1 Sec 9.2 INDIRECT_DATA/Table 9-14. Live data semantics are provided by usb_ocp_recovery_cms_fifo.sv through a future byte adapter.";
        field {
            name = "Indirect data bytes 200-203";
            desc = "Bytes 200-203 of the INDIRECT_DATA transfer window. OCP Recovery v1.1 Sec 9.2 INDIRECT_DATA/Table 9-14.";
            sw = rw;
            hw = rw;
            we = true;
            reset = 32'h00000000;
        } DATA_203_200[31:0];
    } INDIRECT_DATA_50 @ 0x150;

    reg {
        name = "Indirect memory data 51";
        desc = "INDIRECT_DATA bytes 204-207. OCP Recovery v1.1 Sec 9.2 INDIRECT_DATA/Table 9-14. Live data semantics are provided by usb_ocp_recovery_cms_fifo.sv through a future byte adapter.";
        field {
            name = "Indirect data bytes 204-207";
            desc = "Bytes 204-207 of the INDIRECT_DATA transfer window. OCP Recovery v1.1 Sec 9.2 INDIRECT_DATA/Table 9-14.";
            sw = rw;
            hw = rw;
            we = true;
            reset = 32'h00000000;
        } DATA_207_204[31:0];
    } INDIRECT_DATA_51 @ 0x154;

    reg {
        name = "Indirect memory data 52";
        desc = "INDIRECT_DATA bytes 208-211. OCP Recovery v1.1 Sec 9.2 INDIRECT_DATA/Table 9-14. Live data semantics are provided by usb_ocp_recovery_cms_fifo.sv through a future byte adapter.";
        field {
            name = "Indirect data bytes 208-211";
            desc = "Bytes 208-211 of the INDIRECT_DATA transfer window. OCP Recovery v1.1 Sec 9.2 INDIRECT_DATA/Table 9-14.";
            sw = rw;
            hw = rw;
            we = true;
            reset = 32'h00000000;
        } DATA_211_208[31:0];
    } INDIRECT_DATA_52 @ 0x158;

    reg {
        name = "Indirect memory data 53";
        desc = "INDIRECT_DATA bytes 212-215. OCP Recovery v1.1 Sec 9.2 INDIRECT_DATA/Table 9-14. Live data semantics are provided by usb_ocp_recovery_cms_fifo.sv through a future byte adapter.";
        field {
            name = "Indirect data bytes 212-215";
            desc = "Bytes 212-215 of the INDIRECT_DATA transfer window. OCP Recovery v1.1 Sec 9.2 INDIRECT_DATA/Table 9-14.";
            sw = rw;
            hw = rw;
            we = true;
            reset = 32'h00000000;
        } DATA_215_212[31:0];
    } INDIRECT_DATA_53 @ 0x15C;

    reg {
        name = "Indirect memory data 54";
        desc = "INDIRECT_DATA bytes 216-219. OCP Recovery v1.1 Sec 9.2 INDIRECT_DATA/Table 9-14. Live data semantics are provided by usb_ocp_recovery_cms_fifo.sv through a future byte adapter.";
        field {
            name = "Indirect data bytes 216-219";
            desc = "Bytes 216-219 of the INDIRECT_DATA transfer window. OCP Recovery v1.1 Sec 9.2 INDIRECT_DATA/Table 9-14.";
            sw = rw;
            hw = rw;
            we = true;
            reset = 32'h00000000;
        } DATA_219_216[31:0];
    } INDIRECT_DATA_54 @ 0x160;

    reg {
        name = "Indirect memory data 55";
        desc = "INDIRECT_DATA bytes 220-223. OCP Recovery v1.1 Sec 9.2 INDIRECT_DATA/Table 9-14. Live data semantics are provided by usb_ocp_recovery_cms_fifo.sv through a future byte adapter.";
        field {
            name = "Indirect data bytes 220-223";
            desc = "Bytes 220-223 of the INDIRECT_DATA transfer window. OCP Recovery v1.1 Sec 9.2 INDIRECT_DATA/Table 9-14.";
            sw = rw;
            hw = rw;
            we = true;
            reset = 32'h00000000;
        } DATA_223_220[31:0];
    } INDIRECT_DATA_55 @ 0x164;

    reg {
        name = "Indirect memory data 56";
        desc = "INDIRECT_DATA bytes 224-227. OCP Recovery v1.1 Sec 9.2 INDIRECT_DATA/Table 9-14. Live data semantics are provided by usb_ocp_recovery_cms_fifo.sv through a future byte adapter.";
        field {
            name = "Indirect data bytes 224-227";
            desc = "Bytes 224-227 of the INDIRECT_DATA transfer window. OCP Recovery v1.1 Sec 9.2 INDIRECT_DATA/Table 9-14.";
            sw = rw;
            hw = rw;
            we = true;
            reset = 32'h00000000;
        } DATA_227_224[31:0];
    } INDIRECT_DATA_56 @ 0x168;

    reg {
        name = "Indirect memory data 57";
        desc = "INDIRECT_DATA bytes 228-231. OCP Recovery v1.1 Sec 9.2 INDIRECT_DATA/Table 9-14. Live data semantics are provided by usb_ocp_recovery_cms_fifo.sv through a future byte adapter.";
        field {
            name = "Indirect data bytes 228-231";
            desc = "Bytes 228-231 of the INDIRECT_DATA transfer window. OCP Recovery v1.1 Sec 9.2 INDIRECT_DATA/Table 9-14.";
            sw = rw;
            hw = rw;
            we = true;
            reset = 32'h00000000;
        } DATA_231_228[31:0];
    } INDIRECT_DATA_57 @ 0x16C;

    reg {
        name = "Indirect memory data 58";
        desc = "INDIRECT_DATA bytes 232-235. OCP Recovery v1.1 Sec 9.2 INDIRECT_DATA/Table 9-14. Live data semantics are provided by usb_ocp_recovery_cms_fifo.sv through a future byte adapter.";
        field {
            name = "Indirect data bytes 232-235";
            desc = "Bytes 232-235 of the INDIRECT_DATA transfer window. OCP Recovery v1.1 Sec 9.2 INDIRECT_DATA/Table 9-14.";
            sw = rw;
            hw = rw;
            we = true;
            reset = 32'h00000000;
        } DATA_235_232[31:0];
    } INDIRECT_DATA_58 @ 0x170;

    reg {
        name = "Indirect memory data 59";
        desc = "INDIRECT_DATA bytes 236-239. OCP Recovery v1.1 Sec 9.2 INDIRECT_DATA/Table 9-14. Live data semantics are provided by usb_ocp_recovery_cms_fifo.sv through a future byte adapter.";
        field {
            name = "Indirect data bytes 236-239";
            desc = "Bytes 236-239 of the INDIRECT_DATA transfer window. OCP Recovery v1.1 Sec 9.2 INDIRECT_DATA/Table 9-14.";
            sw = rw;
            hw = rw;
            we = true;
            reset = 32'h00000000;
        } DATA_239_236[31:0];
    } INDIRECT_DATA_59 @ 0x174;

    reg {
        name = "Indirect memory data 60";
        desc = "INDIRECT_DATA bytes 240-243. OCP Recovery v1.1 Sec 9.2 INDIRECT_DATA/Table 9-14. Live data semantics are provided by usb_ocp_recovery_cms_fifo.sv through a future byte adapter.";
        field {
            name = "Indirect data bytes 240-243";
            desc = "Bytes 240-243 of the INDIRECT_DATA transfer window. OCP Recovery v1.1 Sec 9.2 INDIRECT_DATA/Table 9-14.";
            sw = rw;
            hw = rw;
            we = true;
            reset = 32'h00000000;
        } DATA_243_240[31:0];
    } INDIRECT_DATA_60 @ 0x178;

    reg {
        name = "Indirect memory data 61";
        desc = "INDIRECT_DATA bytes 244-247. OCP Recovery v1.1 Sec 9.2 INDIRECT_DATA/Table 9-14. Live data semantics are provided by usb_ocp_recovery_cms_fifo.sv through a future byte adapter.";
        field {
            name = "Indirect data bytes 244-247";
            desc = "Bytes 244-247 of the INDIRECT_DATA transfer window. OCP Recovery v1.1 Sec 9.2 INDIRECT_DATA/Table 9-14.";
            sw = rw;
            hw = rw;
            we = true;
            reset = 32'h00000000;
        } DATA_247_244[31:0];
    } INDIRECT_DATA_61 @ 0x17C;

    reg {
        name = "Indirect memory data 62";
        desc = "INDIRECT_DATA bytes 248-251. OCP Recovery v1.1 Sec 9.2 INDIRECT_DATA/Table 9-14. Live data semantics are provided by usb_ocp_recovery_cms_fifo.sv through a future byte adapter.";
        field {
            name = "Indirect data bytes 248-251";
            desc = "Bytes 248-251 of the INDIRECT_DATA transfer window. OCP Recovery v1.1 Sec 9.2 INDIRECT_DATA/Table 9-14.";
            sw = rw;
            hw = rw;
            we = true;
            reset = 32'h00000000;
        } DATA_251_248[31:0];
    } INDIRECT_DATA_62 @ 0x180;

    // INDIRECT_FIFO_CTRL, INDIRECT_FIFO_STATUS, INDIRECT_FIFO_DATA, and VENDOR commands.
    reg {
        name = "Indirect FIFO Control 0";
        desc = "INDIRECT_FIFO_CTRL bytes 0-3: CMS (byte 0), RESET (byte 1), and IMAGE_SIZE[15:0] (bytes 2-3). OCP Recovery v1.1 Sec 9.2 INDIRECT_FIFO_CTRL command summary: IMAGE_SIZE occupies command bytes 2-5 and therefore straddles the two DWORD-aligned control registers. Field placement matches usb_ocp_recovery_cms_fifo.sv.";
        field {
            name = "Component Memory Space";
            desc = "Byte 0 selects the FIFO-backed component memory space. OCP Recovery v1.1 Sec 9.2 INDIRECT_FIFO_CTRL command summary.";
            sw = rw;
            hw = r;
            reset = 8'h00;
        } CMS[7:0];
        field {
            name = "Reset";
            desc = "Byte 1 bit 0 requests FIFO reset and the device clears it after use. The USB transport live behavior is implemented in usb_ocp_recovery_cms_fifo.sv. OCP Recovery v1.1 Sec 9.2 INDIRECT_FIFO_CTRL command summary.";
            sw = rw;
            hw = r;
            onwrite = woclr;
            reset = 8'h00;
        } RESET[15:8];
        field {
            name = "Image Size Low";
            desc = "Bytes 2-3: low 16 bits of IMAGE_SIZE (image size to load, in 4-byte units). OCP Recovery v1.1 Sec 9.2 INDIRECT_FIFO_CTRL command summary places IMAGE_SIZE at command bytes 2-5; this register holds bytes 2-3. Matches usb_ocp_recovery_cms_fifo.sv.";
            sw = rw;
            hw = r;
            reset = 16'h0000;
        } IMAGE_SIZE_LO[31:16];
    } INDIRECT_FIFO_CTRL_0 @ 0x184;

    reg {
        name = "Indirect FIFO Control 1";
        desc = "INDIRECT_FIFO_CTRL bytes 4-7: IMAGE_SIZE[31:16] (bytes 4-5) plus pad bytes 6-7. OCP Recovery v1.1 Sec 9.2 INDIRECT_FIFO_CTRL command summary: IMAGE_SIZE occupies command bytes 2-5 and straddles the two DWORD-aligned control registers. Field placement matches usb_ocp_recovery_cms_fifo.sv.";
        field {
            name = "Image Size High";
            desc = "Bytes 4-5: high 16 bits of IMAGE_SIZE (image size to load, in 4-byte units). OCP Recovery v1.1 Sec 9.2 INDIRECT_FIFO_CTRL command summary places IMAGE_SIZE at command bytes 2-5; this register holds bytes 4-5. Matches usb_ocp_recovery_cms_fifo.sv.";
            sw = rw;
            hw = r;
            reset = 16'h0000;
        } IMAGE_SIZE_HI[15:0];
        field {
            name = "Reserved";
            desc = "Bytes 6-7 are padding introduced by the DWORD-aligned RDL view and are not part of the OCP command payload.";
            sw = r;
            hw = na;
            reset = 16'h0000;
        } RESERVED_31_16[31:16];
    } INDIRECT_FIFO_CTRL_1 @ 0x188;

    reg {
        name = "Indirect FIFO Status 0";
        desc = "INDIRECT_FIFO_STATUS bytes 0-3. OCP Recovery v1.1 Sec 9.2 INDIRECT_FIFO_STATUS command summary, with USB-specific sticky status bits following usb_ocp_recovery_cms_fifo.sv.";
        field {
            name = "FIFO Empty";
            desc = "Byte 0 bit 0 indicates the FIFO is empty. OCP Recovery v1.1 Sec 9.2 INDIRECT_FIFO_STATUS command summary.";
            sw = r;
            hw = w;
            we = false;
            reset = 1'b1;
        } EMPTY[0:0];
        field {
            name = "FIFO Full";
            desc = "Byte 0 bit 1 indicates the FIFO is full. OCP Recovery v1.1 Sec 9.2 INDIRECT_FIFO_STATUS command summary.";
            sw = r;
            hw = w;
            we = false;
            reset = 1'b0;
        } FULL[1:1];
        field {
            name = "Region Reset sticky status";
            desc = "Byte 0 bit 2 is a USB transport sticky status bit cleared by writing 1 to status byte 0, matching usb_ocp_recovery_cms_fifo.sv.";
            sw = r;
            hw = w;
            we = false;
            reset = 1'b0;
        } REGION_RESET[2:2];
        field {
            name = "Overflow sticky status";
            desc = "Byte 0 bit 3 is a USB transport sticky overflow bit cleared by writing 1 to status byte 0, matching usb_ocp_recovery_cms_fifo.sv.";
            sw = r;
            hw = w;
            we = false;
            reset = 1'b0;
        } OVERFLOW[3:3];
        field {
            name = "Image done sticky status";
            desc = "Byte 0 bit 4 is a USB transport sticky image-done bit cleared by writing 1 to status byte 0, matching usb_ocp_recovery_cms_fifo.sv.";
            sw = r;
            hw = w;
            we = false;
            reset = 1'b0;
        } IMAGE_DONE[4:4];
        field {
            name = "Reserved status bits";
            desc = "Byte 0 bits 7:5 are reserved in this USB transport view.";
            sw = r;
            hw = w;
            we = false;
            reset = 3'h0;
        } RESERVED_7_5[7:5];
        field {
            name = "Region type";
            desc = "Byte 1 reports the selected FIFO region type. The current USB implementation returns 0x00 for code space. OCP Recovery v1.1 Sec 9.2 INDIRECT_FIFO_STATUS command summary and usb_ocp_recovery_cms_fifo.sv.";
            sw = r;
            hw = w;
            we = false;
            reset = 8'h00;
        } REGION_TYPE[15:8];
        field {
            name = "Reserved";
            desc = "Bytes 2-3 are reserved. OCP Recovery v1.1 Sec 9.2 INDIRECT_FIFO_STATUS command summary.";
            sw = r;
            hw = w;
            we = false;
            reset = 16'h0000;
        } RESERVED_31_16[31:16];
    } INDIRECT_FIFO_STATUS_0 @ 0x18C;

    reg {
        name = "Indirect FIFO Status 1";
        desc = "INDIRECT_FIFO_STATUS bytes 4-7. OCP Recovery v1.1 Sec 9.2 INDIRECT_FIFO_STATUS command summary.";
        field {
            name = "Write Index";
            desc = "Bytes 4-7 report WRITE_INDEX in 4-byte units. OCP Recovery v1.1 Sec 9.2 INDIRECT_FIFO_STATUS command summary.";
            sw = r;
            hw = w;
            we = false;
            reset = 32'h00000000;
        } WRITE_INDEX[31:0];
    } INDIRECT_FIFO_STATUS_1 @ 0x190;

    reg {
        name = "Indirect FIFO Status 2";
        desc = "INDIRECT_FIFO_STATUS bytes 8-11. OCP Recovery v1.1 Sec 9.2 INDIRECT_FIFO_STATUS command summary.";
        field {
            name = "Read Index";
            desc = "Bytes 8-11 report READ_INDEX in 4-byte units. OCP Recovery v1.1 Sec 9.2 INDIRECT_FIFO_STATUS command summary.";
            sw = r;
            hw = w;
            we = false;
            reset = 32'h00000000;
        } READ_INDEX[31:0];
    } INDIRECT_FIFO_STATUS_2 @ 0x194;

    reg {
        name = "Indirect FIFO Status 3";
        desc = "INDIRECT_FIFO_STATUS bytes 12-15. OCP Recovery v1.1 Sec 9.2 INDIRECT_FIFO_STATUS command summary.";
        field {
            name = "FIFO size";
            desc = "Bytes 12-15 report FIFO_SIZE in 4-byte units. OCP Recovery v1.1 Sec 9.2 INDIRECT_FIFO_STATUS command summary.";
            sw = r;
            hw = w;
            we = false;
            reset = 32'h00000000;
        } FIFO_SIZE[31:0];
    } INDIRECT_FIFO_STATUS_3 @ 0x198;

    reg {
        name = "Indirect FIFO Status 4";
        desc = "INDIRECT_FIFO_STATUS bytes 16-19. OCP Recovery v1.1 Sec 9.2 INDIRECT_FIFO_STATUS command summary.";
        field {
            name = "Max transfer size";
            desc = "Bytes 16-19 report MAX_TRANSFER_SIZE in 4-byte units. OCP Recovery v1.1 Sec 9.2 INDIRECT_FIFO_STATUS command summary.";
            sw = r;
            hw = w;
            we = false;
            reset = 32'h00000000;
        } MAX_TRANSFER_SIZE[31:0];
    } INDIRECT_FIFO_STATUS_4 @ 0x19C;

    reg {
        name = "Indirect FIFO Data";
        desc = "INDIRECT_FIFO_DATA placeholder register. OCP Recovery v1.1 Sec 9.2 INDIRECT_FIFO_DATA command summary. This register exists only to publish a SOC_USB_OCP_RECOVERY_INDIRECT_FIFO_DATA address symbol and to anchor the offset in the aperture map; the live byte-mux and pointer-update logic live in usb_ocp_recovery_cms_fifo.sv.";
        field {
            name = "FIFO data placeholder";
            desc = "DWORD placeholder for INDIRECT_FIFO_DATA. The generated adapter must hand this address to the live usb_ocp_recovery_cms_fifo.sv data path rather than infer storage here.";
            sw = rw;
            hw = rw;
            we = true;
            reset = 32'h00000000;
        } DATA[31:0];
    } INDIRECT_FIFO_DATA @ 0x1A0;

    reg {
        name = "Vendor command placeholder";
        desc = "One-byte VENDOR placeholder per Phase 1b D0.I.bis. OCP Recovery v1.1 Sec 9.2 VENDOR command summary. This project intentionally trims the VENDOR aperture to a single byte placeholder and leaves expansion for a later phase.";
        field {
            name = "Vendor placeholder byte";
            desc = "Byte 0 placeholder for the vendor-defined command space. This project currently models only one byte, reset to 0. OCP Recovery v1.1 Sec 9.2 VENDOR command summary.";
            sw = rw;
            hw = na;
            reset = 8'h00;
        } VENDOR_DATA[7:0];
        field {
            name = "Reserved";
            desc = "Bytes 1-3 are padding introduced by the DWORD-aligned RDL view and are not part of the current placeholder payload.";
            sw = r;
            hw = na;
            reset = 24'h000000;
        } RESERVED_31_8[31:8];
    } VENDOR @ 0x1A4;

    reg {
        name = "Window size pad";
        desc = "Padding register used only to force the elaborated usb_ocp_recovery addrmap size to a natural 4 KiB window ending at offset 0xFFC.";
        field {
            name = "Reserved pad";
            desc = "Not part of the OCP Recovery register set. This filler forces a 4 KiB elaborated addrmap for the SoC AHB sub-decoder window.";
            sw = r;
            hw = na;
            reset = 32'h00000000;
        } DATA[31:0];
    } WINDOW_PAD @ 0xFFC;

};
